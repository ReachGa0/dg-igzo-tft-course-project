* IGZO n-TFT transfer
.include ../models/tft_models.inc
.options gmin=1e-12 abstol=1e-14 reltol=1e-4 method=trap

VD d 0 0.1
VG g 0 0
X1 d g 0 igzo_tft
.control
set noaskquit
dc VG -3 3.3 0.05 VD 0.1 3.3 0.8
wrdata ../../data/igzo_transfer_raw.dat v(g) v(d) i(vd)
quit
.endc
.end
