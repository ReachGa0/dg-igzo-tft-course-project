* IGZO n-TFT output
.include ../models/tft_models.inc
.options gmin=1e-12 abstol=1e-14 reltol=1e-4 method=trap

VD d 0 0
VG g 0 0.1
X1 d g 0 igzo_tft
.control
set noaskquit
dc VD 0 6 0.05 VG 0.1 3.299 0.457
wrdata ../../data/igzo_output_raw.dat v(d) v(g) i(vd)
quit
.endc
.end
