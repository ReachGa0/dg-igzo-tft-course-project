* 02_igzo_output.cir
* IGZO N-type TFT output characteristic.
* Target raw data: N/output raw data.csv
* Sweep: VDS=0..6 V, VGS=0.1..3.299 V.

.include models_tft.inc

* Reverse VDS source polarity so i(VDS) is positive for N-channel drain current.
VDS 0 d DC 0
VGS g 0 DC 0

M1 d g 0 0 IGZO_N L={LN} W={WN}

.dc VDS 0 -6 -0.1 VGS 0.1 3.299 0.457
.plot dc i(VDS)
