* M01 route-divergence root-cause R02 xyce
.include "spice/models/igzo_dg_behavioral_r02.inc"
* IGZO-only M00 behavioral translation candidate R02
* M01_EXECUTION_REQUIRED: not executed or simulator-validated in M00.
* This is not native HSPICE Level 61 and is not a physical parameter card.
* Formal fitted domain: VDS=0..0.2 V, L=8..12 um, 300 K, ideal contacts.
.subckt IGZO_DG_PORTABLE_PROBE_R02 D TG BG S params: WUM=60 LUM=10
.param M00_LOGBETA=-2.714306573073809
.param M00_VTHDG=-0.01927992032790904
.param M00_ETA=0.5625448525612822
.param M00_SOFT=0.04494641359747736
.param M00_GAMMA=1.734644192947173
.param M00_KD=1.245313399341948
.param M00_LAMBDA=1.633254178584633e-33
.param M00_LOGGMIN=-29.99103683657538
.param M00_KVTHL=-0.04180975787015793
.func RCA_Q(x,s) {s*ln(1+exp(min(max(x/s,-60),60)))}
BPORT D S I={sgn(V(D,S))*WUM*1e-4*(pow(10,M00_LOGBETA)*(10/LUM)*(pow(RCA_Q(M00_ETA*(V(TG,S)+V(BG,S))-M00_VTHDG-M00_KVTHL*ln(LUM/10),M00_SOFT),M00_GAMMA)-pow(RCA_Q(M00_ETA*(V(TG,S)+V(BG,S))-M00_VTHDG-M00_KVTHL*ln(LUM/10)-M00_KD*abs(V(D,S)),M00_SOFT),M00_GAMMA))*(1+M00_LAMBDA*abs(V(D,S)))+pow(10,M00_LOGGMIN)*abs(V(D,S)))}
.ends IGZO_DG_PORTABLE_PROBE_R02
.option numdgt=17
VSWEEP SWEEP 0 0
.func RCA_LIMIT_PROBE(x) {limit(x,-60,60)}
.func RCA_CLAMP_PROBE(x) {min(max(x,-60),60)}
BLOLIMIT LO_LIMIT 0 V={RCA_LIMIT_PROBE(-75)}
BLOCLAMP LO_CLAMP 0 V={RCA_CLAMP_PROBE(-75)}
BMIDLIMIT MID_LIMIT 0 V={RCA_LIMIT_PROBE(0.25)}
BMIDCLAMP MID_CLAMP 0 V={RCA_CLAMP_PROBE(0.25)}
BHILIMIT HI_LIMIT 0 V={RCA_LIMIT_PROBE(75)}
BHICLAMP HI_CLAMP 0 V={RCA_CLAMP_PROBE(75)}
VSENSE NSENSE 0 1
RSENSE NSENSE 0 1000
VORIG0 DORIG0 0 0.01
VTORIG0 TORIG0 0 0
VBORIG0 BORIG0 0 0
VPORT0 DPORT0 0 0.01
VTPORT0 TPORT0 0 0
VBPORT0 BPORT0 0 0
XORIG0 DORIG0 TORIG0 BORIG0 0 IGZO_DG_BEHAVIORAL_R02 WUM=60 LUM=10
XPORT0 DPORT0 TPORT0 BPORT0 0 IGZO_DG_PORTABLE_PROBE_R02 WUM=60 LUM=10
VORIG1 DORIG1 0 0.20000000000000001
VTORIG1 TORIG1 0 0.5
VBORIG1 BORIG1 0 0
VPORT1 DPORT1 0 0.20000000000000001
VTPORT1 TPORT1 0 0.5
VBPORT1 BPORT1 0 0
XORIG1 DORIG1 TORIG1 BORIG1 0 IGZO_DG_BEHAVIORAL_R02 WUM=60 LUM=10
XPORT1 DPORT1 TPORT1 BPORT1 0 IGZO_DG_PORTABLE_PROBE_R02 WUM=60 LUM=10
VORIG2 DORIG2 0 0.20000000000000001
VTORIG2 TORIG2 0 0.5
VBORIG2 BORIG2 0 0.5
VPORT2 DPORT2 0 0.20000000000000001
VTPORT2 TPORT2 0 0.5
VBPORT2 BPORT2 0 0.5
XORIG2 DORIG2 TORIG2 BORIG2 0 IGZO_DG_BEHAVIORAL_R02 WUM=60 LUM=10
XPORT2 DPORT2 TPORT2 BPORT2 0 IGZO_DG_PORTABLE_PROBE_R02 WUM=60 LUM=10
.DC VSWEEP 0 0 1
.PRINT DC FORMAT=NOINDEX PRECISION=17 V(LO_LIMIT) V(LO_CLAMP) V(MID_LIMIT) V(MID_CLAMP) V(HI_LIMIT) V(HI_CLAMP)
+ I(VSENSE) I(VORIG0) I(VPORT0) I(VORIG1) I(VPORT1) I(VORIG2)
+ I(VPORT2)
.end
