* C00 R03 ngspice IGZO-only active-load inverter transient
.include spice/models/igzo_dg_behavioral_r03_portable.inc
.option numdgt=17
VDDV100T050R0125C0500 VDV100T050R0125C0500 0 0.10000000000000001
VTPV100T050R0125C0500 VTV100T050R0125C0500 0 0.050000000000000003
VINV100T050R0125C0500 VIV100T050R0125C0500 0 PULSE(0 0.10000000000000001 2.4999999999999999e-07 1e-08 1e-08 6.9999999999999997e-07 1.5e-06)
XLDV100T050R0125C0500 VDV100T050R0125C0500 VTV100T050R0125C0500 VDV100T050R0125C0500 VOV100T050R0125C0500 IGZO_DG_BEHAVIORAL_R03_PORTABLE WUM=7.5 LUM=10
XDRV100T050R0125C0500 VOV100T050R0125C0500 VIV100T050R0125C0500 0 0 IGZO_DG_BEHAVIORAL_R03_PORTABLE WUM=60 LUM=10
CLOADV100T050R0125C0500 VOV100T050R0125C0500 0 4.9999999999999999e-13
VDDV100T050R0125C1000 VDV100T050R0125C1000 0 0.10000000000000001
VTPV100T050R0125C1000 VTV100T050R0125C1000 0 0.050000000000000003
VINV100T050R0125C1000 VIV100T050R0125C1000 0 PULSE(0 0.10000000000000001 2.4999999999999999e-07 1e-08 1e-08 6.9999999999999997e-07 1.5e-06)
XLDV100T050R0125C1000 VDV100T050R0125C1000 VTV100T050R0125C1000 VDV100T050R0125C1000 VOV100T050R0125C1000 IGZO_DG_BEHAVIORAL_R03_PORTABLE WUM=7.5 LUM=10
XDRV100T050R0125C1000 VOV100T050R0125C1000 VIV100T050R0125C1000 0 0 IGZO_DG_BEHAVIORAL_R03_PORTABLE WUM=60 LUM=10
CLOADV100T050R0125C1000 VOV100T050R0125C1000 0 9.9999999999999998e-13
VDDV100T050R0250C0500 VDV100T050R0250C0500 0 0.10000000000000001
VTPV100T050R0250C0500 VTV100T050R0250C0500 0 0.050000000000000003
VINV100T050R0250C0500 VIV100T050R0250C0500 0 PULSE(0 0.10000000000000001 2.4999999999999999e-07 1e-08 1e-08 6.9999999999999997e-07 1.5e-06)
XLDV100T050R0250C0500 VDV100T050R0250C0500 VTV100T050R0250C0500 VDV100T050R0250C0500 VOV100T050R0250C0500 IGZO_DG_BEHAVIORAL_R03_PORTABLE WUM=15 LUM=10
XDRV100T050R0250C0500 VOV100T050R0250C0500 VIV100T050R0250C0500 0 0 IGZO_DG_BEHAVIORAL_R03_PORTABLE WUM=60 LUM=10
CLOADV100T050R0250C0500 VOV100T050R0250C0500 0 4.9999999999999999e-13
VDDV100T050R0250C1000 VDV100T050R0250C1000 0 0.10000000000000001
VTPV100T050R0250C1000 VTV100T050R0250C1000 0 0.050000000000000003
VINV100T050R0250C1000 VIV100T050R0250C1000 0 PULSE(0 0.10000000000000001 2.4999999999999999e-07 1e-08 1e-08 6.9999999999999997e-07 1.5e-06)
XLDV100T050R0250C1000 VDV100T050R0250C1000 VTV100T050R0250C1000 VDV100T050R0250C1000 VOV100T050R0250C1000 IGZO_DG_BEHAVIORAL_R03_PORTABLE WUM=15 LUM=10
XDRV100T050R0250C1000 VOV100T050R0250C1000 VIV100T050R0250C1000 0 0 IGZO_DG_BEHAVIORAL_R03_PORTABLE WUM=60 LUM=10
CLOADV100T050R0250C1000 VOV100T050R0250C1000 0 9.9999999999999998e-13
VDDV100T050R0500C0500 VDV100T050R0500C0500 0 0.10000000000000001
VTPV100T050R0500C0500 VTV100T050R0500C0500 0 0.050000000000000003
VINV100T050R0500C0500 VIV100T050R0500C0500 0 PULSE(0 0.10000000000000001 2.4999999999999999e-07 1e-08 1e-08 6.9999999999999997e-07 1.5e-06)
XLDV100T050R0500C0500 VDV100T050R0500C0500 VTV100T050R0500C0500 VDV100T050R0500C0500 VOV100T050R0500C0500 IGZO_DG_BEHAVIORAL_R03_PORTABLE WUM=30 LUM=10
XDRV100T050R0500C0500 VOV100T050R0500C0500 VIV100T050R0500C0500 0 0 IGZO_DG_BEHAVIORAL_R03_PORTABLE WUM=60 LUM=10
CLOADV100T050R0500C0500 VOV100T050R0500C0500 0 4.9999999999999999e-13
VDDV100T050R0500C1000 VDV100T050R0500C1000 0 0.10000000000000001
VTPV100T050R0500C1000 VTV100T050R0500C1000 0 0.050000000000000003
VINV100T050R0500C1000 VIV100T050R0500C1000 0 PULSE(0 0.10000000000000001 2.4999999999999999e-07 1e-08 1e-08 6.9999999999999997e-07 1.5e-06)
XLDV100T050R0500C1000 VDV100T050R0500C1000 VTV100T050R0500C1000 VDV100T050R0500C1000 VOV100T050R0500C1000 IGZO_DG_BEHAVIORAL_R03_PORTABLE WUM=30 LUM=10
XDRV100T050R0500C1000 VOV100T050R0500C1000 VIV100T050R0500C1000 0 0 IGZO_DG_BEHAVIORAL_R03_PORTABLE WUM=60 LUM=10
CLOADV100T050R0500C1000 VOV100T050R0500C1000 0 9.9999999999999998e-13
VDDV100T075R0125C0500 VDV100T075R0125C0500 0 0.10000000000000001
VTPV100T075R0125C0500 VTV100T075R0125C0500 0 0.075000000000000011
VINV100T075R0125C0500 VIV100T075R0125C0500 0 PULSE(0 0.10000000000000001 2.4999999999999999e-07 1e-08 1e-08 6.9999999999999997e-07 1.5e-06)
XLDV100T075R0125C0500 VDV100T075R0125C0500 VTV100T075R0125C0500 VDV100T075R0125C0500 VOV100T075R0125C0500 IGZO_DG_BEHAVIORAL_R03_PORTABLE WUM=7.5 LUM=10
XDRV100T075R0125C0500 VOV100T075R0125C0500 VIV100T075R0125C0500 0 0 IGZO_DG_BEHAVIORAL_R03_PORTABLE WUM=60 LUM=10
CLOADV100T075R0125C0500 VOV100T075R0125C0500 0 4.9999999999999999e-13
VDDV100T075R0125C1000 VDV100T075R0125C1000 0 0.10000000000000001
VTPV100T075R0125C1000 VTV100T075R0125C1000 0 0.075000000000000011
VINV100T075R0125C1000 VIV100T075R0125C1000 0 PULSE(0 0.10000000000000001 2.4999999999999999e-07 1e-08 1e-08 6.9999999999999997e-07 1.5e-06)
XLDV100T075R0125C1000 VDV100T075R0125C1000 VTV100T075R0125C1000 VDV100T075R0125C1000 VOV100T075R0125C1000 IGZO_DG_BEHAVIORAL_R03_PORTABLE WUM=7.5 LUM=10
XDRV100T075R0125C1000 VOV100T075R0125C1000 VIV100T075R0125C1000 0 0 IGZO_DG_BEHAVIORAL_R03_PORTABLE WUM=60 LUM=10
CLOADV100T075R0125C1000 VOV100T075R0125C1000 0 9.9999999999999998e-13
VDDV100T075R0250C0500 VDV100T075R0250C0500 0 0.10000000000000001
VTPV100T075R0250C0500 VTV100T075R0250C0500 0 0.075000000000000011
VINV100T075R0250C0500 VIV100T075R0250C0500 0 PULSE(0 0.10000000000000001 2.4999999999999999e-07 1e-08 1e-08 6.9999999999999997e-07 1.5e-06)
XLDV100T075R0250C0500 VDV100T075R0250C0500 VTV100T075R0250C0500 VDV100T075R0250C0500 VOV100T075R0250C0500 IGZO_DG_BEHAVIORAL_R03_PORTABLE WUM=15 LUM=10
XDRV100T075R0250C0500 VOV100T075R0250C0500 VIV100T075R0250C0500 0 0 IGZO_DG_BEHAVIORAL_R03_PORTABLE WUM=60 LUM=10
CLOADV100T075R0250C0500 VOV100T075R0250C0500 0 4.9999999999999999e-13
VDDV100T075R0250C1000 VDV100T075R0250C1000 0 0.10000000000000001
VTPV100T075R0250C1000 VTV100T075R0250C1000 0 0.075000000000000011
VINV100T075R0250C1000 VIV100T075R0250C1000 0 PULSE(0 0.10000000000000001 2.4999999999999999e-07 1e-08 1e-08 6.9999999999999997e-07 1.5e-06)
XLDV100T075R0250C1000 VDV100T075R0250C1000 VTV100T075R0250C1000 VDV100T075R0250C1000 VOV100T075R0250C1000 IGZO_DG_BEHAVIORAL_R03_PORTABLE WUM=15 LUM=10
XDRV100T075R0250C1000 VOV100T075R0250C1000 VIV100T075R0250C1000 0 0 IGZO_DG_BEHAVIORAL_R03_PORTABLE WUM=60 LUM=10
CLOADV100T075R0250C1000 VOV100T075R0250C1000 0 9.9999999999999998e-13
VDDV100T075R0500C0500 VDV100T075R0500C0500 0 0.10000000000000001
VTPV100T075R0500C0500 VTV100T075R0500C0500 0 0.075000000000000011
VINV100T075R0500C0500 VIV100T075R0500C0500 0 PULSE(0 0.10000000000000001 2.4999999999999999e-07 1e-08 1e-08 6.9999999999999997e-07 1.5e-06)
XLDV100T075R0500C0500 VDV100T075R0500C0500 VTV100T075R0500C0500 VDV100T075R0500C0500 VOV100T075R0500C0500 IGZO_DG_BEHAVIORAL_R03_PORTABLE WUM=30 LUM=10
XDRV100T075R0500C0500 VOV100T075R0500C0500 VIV100T075R0500C0500 0 0 IGZO_DG_BEHAVIORAL_R03_PORTABLE WUM=60 LUM=10
CLOADV100T075R0500C0500 VOV100T075R0500C0500 0 4.9999999999999999e-13
VDDV100T075R0500C1000 VDV100T075R0500C1000 0 0.10000000000000001
VTPV100T075R0500C1000 VTV100T075R0500C1000 0 0.075000000000000011
VINV100T075R0500C1000 VIV100T075R0500C1000 0 PULSE(0 0.10000000000000001 2.4999999999999999e-07 1e-08 1e-08 6.9999999999999997e-07 1.5e-06)
XLDV100T075R0500C1000 VDV100T075R0500C1000 VTV100T075R0500C1000 VDV100T075R0500C1000 VOV100T075R0500C1000 IGZO_DG_BEHAVIORAL_R03_PORTABLE WUM=30 LUM=10
XDRV100T075R0500C1000 VOV100T075R0500C1000 VIV100T075R0500C1000 0 0 IGZO_DG_BEHAVIORAL_R03_PORTABLE WUM=60 LUM=10
CLOADV100T075R0500C1000 VOV100T075R0500C1000 0 9.9999999999999998e-13
VDDV100T100R0125C0500 VDV100T100R0125C0500 0 0.10000000000000001
VTPV100T100R0125C0500 VTV100T100R0125C0500 0 0.10000000000000001
VINV100T100R0125C0500 VIV100T100R0125C0500 0 PULSE(0 0.10000000000000001 2.4999999999999999e-07 1e-08 1e-08 6.9999999999999997e-07 1.5e-06)
XLDV100T100R0125C0500 VDV100T100R0125C0500 VTV100T100R0125C0500 VDV100T100R0125C0500 VOV100T100R0125C0500 IGZO_DG_BEHAVIORAL_R03_PORTABLE WUM=7.5 LUM=10
XDRV100T100R0125C0500 VOV100T100R0125C0500 VIV100T100R0125C0500 0 0 IGZO_DG_BEHAVIORAL_R03_PORTABLE WUM=60 LUM=10
CLOADV100T100R0125C0500 VOV100T100R0125C0500 0 4.9999999999999999e-13
VDDV100T100R0125C1000 VDV100T100R0125C1000 0 0.10000000000000001
VTPV100T100R0125C1000 VTV100T100R0125C1000 0 0.10000000000000001
VINV100T100R0125C1000 VIV100T100R0125C1000 0 PULSE(0 0.10000000000000001 2.4999999999999999e-07 1e-08 1e-08 6.9999999999999997e-07 1.5e-06)
XLDV100T100R0125C1000 VDV100T100R0125C1000 VTV100T100R0125C1000 VDV100T100R0125C1000 VOV100T100R0125C1000 IGZO_DG_BEHAVIORAL_R03_PORTABLE WUM=7.5 LUM=10
XDRV100T100R0125C1000 VOV100T100R0125C1000 VIV100T100R0125C1000 0 0 IGZO_DG_BEHAVIORAL_R03_PORTABLE WUM=60 LUM=10
CLOADV100T100R0125C1000 VOV100T100R0125C1000 0 9.9999999999999998e-13
VDDV100T100R0250C0500 VDV100T100R0250C0500 0 0.10000000000000001
VTPV100T100R0250C0500 VTV100T100R0250C0500 0 0.10000000000000001
VINV100T100R0250C0500 VIV100T100R0250C0500 0 PULSE(0 0.10000000000000001 2.4999999999999999e-07 1e-08 1e-08 6.9999999999999997e-07 1.5e-06)
XLDV100T100R0250C0500 VDV100T100R0250C0500 VTV100T100R0250C0500 VDV100T100R0250C0500 VOV100T100R0250C0500 IGZO_DG_BEHAVIORAL_R03_PORTABLE WUM=15 LUM=10
XDRV100T100R0250C0500 VOV100T100R0250C0500 VIV100T100R0250C0500 0 0 IGZO_DG_BEHAVIORAL_R03_PORTABLE WUM=60 LUM=10
CLOADV100T100R0250C0500 VOV100T100R0250C0500 0 4.9999999999999999e-13
VDDV100T100R0250C1000 VDV100T100R0250C1000 0 0.10000000000000001
VTPV100T100R0250C1000 VTV100T100R0250C1000 0 0.10000000000000001
VINV100T100R0250C1000 VIV100T100R0250C1000 0 PULSE(0 0.10000000000000001 2.4999999999999999e-07 1e-08 1e-08 6.9999999999999997e-07 1.5e-06)
XLDV100T100R0250C1000 VDV100T100R0250C1000 VTV100T100R0250C1000 VDV100T100R0250C1000 VOV100T100R0250C1000 IGZO_DG_BEHAVIORAL_R03_PORTABLE WUM=15 LUM=10
XDRV100T100R0250C1000 VOV100T100R0250C1000 VIV100T100R0250C1000 0 0 IGZO_DG_BEHAVIORAL_R03_PORTABLE WUM=60 LUM=10
CLOADV100T100R0250C1000 VOV100T100R0250C1000 0 9.9999999999999998e-13
VDDV100T100R0500C0500 VDV100T100R0500C0500 0 0.10000000000000001
VTPV100T100R0500C0500 VTV100T100R0500C0500 0 0.10000000000000001
VINV100T100R0500C0500 VIV100T100R0500C0500 0 PULSE(0 0.10000000000000001 2.4999999999999999e-07 1e-08 1e-08 6.9999999999999997e-07 1.5e-06)
XLDV100T100R0500C0500 VDV100T100R0500C0500 VTV100T100R0500C0500 VDV100T100R0500C0500 VOV100T100R0500C0500 IGZO_DG_BEHAVIORAL_R03_PORTABLE WUM=30 LUM=10
XDRV100T100R0500C0500 VOV100T100R0500C0500 VIV100T100R0500C0500 0 0 IGZO_DG_BEHAVIORAL_R03_PORTABLE WUM=60 LUM=10
CLOADV100T100R0500C0500 VOV100T100R0500C0500 0 4.9999999999999999e-13
VDDV100T100R0500C1000 VDV100T100R0500C1000 0 0.10000000000000001
VTPV100T100R0500C1000 VTV100T100R0500C1000 0 0.10000000000000001
VINV100T100R0500C1000 VIV100T100R0500C1000 0 PULSE(0 0.10000000000000001 2.4999999999999999e-07 1e-08 1e-08 6.9999999999999997e-07 1.5e-06)
XLDV100T100R0500C1000 VDV100T100R0500C1000 VTV100T100R0500C1000 VDV100T100R0500C1000 VOV100T100R0500C1000 IGZO_DG_BEHAVIORAL_R03_PORTABLE WUM=30 LUM=10
XDRV100T100R0500C1000 VOV100T100R0500C1000 VIV100T100R0500C1000 0 0 IGZO_DG_BEHAVIORAL_R03_PORTABLE WUM=60 LUM=10
CLOADV100T100R0500C1000 VOV100T100R0500C1000 0 9.9999999999999998e-13
VDDV200T050R0125C0500 VDV200T050R0125C0500 0 0.20000000000000001
VTPV200T050R0125C0500 VTV200T050R0125C0500 0 0.10000000000000001
VINV200T050R0125C0500 VIV200T050R0125C0500 0 PULSE(0 0.20000000000000001 2.4999999999999999e-07 1e-08 1e-08 6.9999999999999997e-07 1.5e-06)
XLDV200T050R0125C0500 VDV200T050R0125C0500 VTV200T050R0125C0500 VDV200T050R0125C0500 VOV200T050R0125C0500 IGZO_DG_BEHAVIORAL_R03_PORTABLE WUM=7.5 LUM=10
XDRV200T050R0125C0500 VOV200T050R0125C0500 VIV200T050R0125C0500 0 0 IGZO_DG_BEHAVIORAL_R03_PORTABLE WUM=60 LUM=10
CLOADV200T050R0125C0500 VOV200T050R0125C0500 0 4.9999999999999999e-13
VDDV200T050R0125C1000 VDV200T050R0125C1000 0 0.20000000000000001
VTPV200T050R0125C1000 VTV200T050R0125C1000 0 0.10000000000000001
VINV200T050R0125C1000 VIV200T050R0125C1000 0 PULSE(0 0.20000000000000001 2.4999999999999999e-07 1e-08 1e-08 6.9999999999999997e-07 1.5e-06)
XLDV200T050R0125C1000 VDV200T050R0125C1000 VTV200T050R0125C1000 VDV200T050R0125C1000 VOV200T050R0125C1000 IGZO_DG_BEHAVIORAL_R03_PORTABLE WUM=7.5 LUM=10
XDRV200T050R0125C1000 VOV200T050R0125C1000 VIV200T050R0125C1000 0 0 IGZO_DG_BEHAVIORAL_R03_PORTABLE WUM=60 LUM=10
CLOADV200T050R0125C1000 VOV200T050R0125C1000 0 9.9999999999999998e-13
VDDV200T050R0250C0500 VDV200T050R0250C0500 0 0.20000000000000001
VTPV200T050R0250C0500 VTV200T050R0250C0500 0 0.10000000000000001
VINV200T050R0250C0500 VIV200T050R0250C0500 0 PULSE(0 0.20000000000000001 2.4999999999999999e-07 1e-08 1e-08 6.9999999999999997e-07 1.5e-06)
XLDV200T050R0250C0500 VDV200T050R0250C0500 VTV200T050R0250C0500 VDV200T050R0250C0500 VOV200T050R0250C0500 IGZO_DG_BEHAVIORAL_R03_PORTABLE WUM=15 LUM=10
XDRV200T050R0250C0500 VOV200T050R0250C0500 VIV200T050R0250C0500 0 0 IGZO_DG_BEHAVIORAL_R03_PORTABLE WUM=60 LUM=10
CLOADV200T050R0250C0500 VOV200T050R0250C0500 0 4.9999999999999999e-13
VDDV200T050R0250C1000 VDV200T050R0250C1000 0 0.20000000000000001
VTPV200T050R0250C1000 VTV200T050R0250C1000 0 0.10000000000000001
VINV200T050R0250C1000 VIV200T050R0250C1000 0 PULSE(0 0.20000000000000001 2.4999999999999999e-07 1e-08 1e-08 6.9999999999999997e-07 1.5e-06)
XLDV200T050R0250C1000 VDV200T050R0250C1000 VTV200T050R0250C1000 VDV200T050R0250C1000 VOV200T050R0250C1000 IGZO_DG_BEHAVIORAL_R03_PORTABLE WUM=15 LUM=10
XDRV200T050R0250C1000 VOV200T050R0250C1000 VIV200T050R0250C1000 0 0 IGZO_DG_BEHAVIORAL_R03_PORTABLE WUM=60 LUM=10
CLOADV200T050R0250C1000 VOV200T050R0250C1000 0 9.9999999999999998e-13
VDDV200T050R0500C0500 VDV200T050R0500C0500 0 0.20000000000000001
VTPV200T050R0500C0500 VTV200T050R0500C0500 0 0.10000000000000001
VINV200T050R0500C0500 VIV200T050R0500C0500 0 PULSE(0 0.20000000000000001 2.4999999999999999e-07 1e-08 1e-08 6.9999999999999997e-07 1.5e-06)
XLDV200T050R0500C0500 VDV200T050R0500C0500 VTV200T050R0500C0500 VDV200T050R0500C0500 VOV200T050R0500C0500 IGZO_DG_BEHAVIORAL_R03_PORTABLE WUM=30 LUM=10
XDRV200T050R0500C0500 VOV200T050R0500C0500 VIV200T050R0500C0500 0 0 IGZO_DG_BEHAVIORAL_R03_PORTABLE WUM=60 LUM=10
CLOADV200T050R0500C0500 VOV200T050R0500C0500 0 4.9999999999999999e-13
VDDV200T050R0500C1000 VDV200T050R0500C1000 0 0.20000000000000001
VTPV200T050R0500C1000 VTV200T050R0500C1000 0 0.10000000000000001
VINV200T050R0500C1000 VIV200T050R0500C1000 0 PULSE(0 0.20000000000000001 2.4999999999999999e-07 1e-08 1e-08 6.9999999999999997e-07 1.5e-06)
XLDV200T050R0500C1000 VDV200T050R0500C1000 VTV200T050R0500C1000 VDV200T050R0500C1000 VOV200T050R0500C1000 IGZO_DG_BEHAVIORAL_R03_PORTABLE WUM=30 LUM=10
XDRV200T050R0500C1000 VOV200T050R0500C1000 VIV200T050R0500C1000 0 0 IGZO_DG_BEHAVIORAL_R03_PORTABLE WUM=60 LUM=10
CLOADV200T050R0500C1000 VOV200T050R0500C1000 0 9.9999999999999998e-13
VDDV200T075R0125C0500 VDV200T075R0125C0500 0 0.20000000000000001
VTPV200T075R0125C0500 VTV200T075R0125C0500 0 0.15000000000000002
VINV200T075R0125C0500 VIV200T075R0125C0500 0 PULSE(0 0.20000000000000001 2.4999999999999999e-07 1e-08 1e-08 6.9999999999999997e-07 1.5e-06)
XLDV200T075R0125C0500 VDV200T075R0125C0500 VTV200T075R0125C0500 VDV200T075R0125C0500 VOV200T075R0125C0500 IGZO_DG_BEHAVIORAL_R03_PORTABLE WUM=7.5 LUM=10
XDRV200T075R0125C0500 VOV200T075R0125C0500 VIV200T075R0125C0500 0 0 IGZO_DG_BEHAVIORAL_R03_PORTABLE WUM=60 LUM=10
CLOADV200T075R0125C0500 VOV200T075R0125C0500 0 4.9999999999999999e-13
VDDV200T075R0125C1000 VDV200T075R0125C1000 0 0.20000000000000001
VTPV200T075R0125C1000 VTV200T075R0125C1000 0 0.15000000000000002
VINV200T075R0125C1000 VIV200T075R0125C1000 0 PULSE(0 0.20000000000000001 2.4999999999999999e-07 1e-08 1e-08 6.9999999999999997e-07 1.5e-06)
XLDV200T075R0125C1000 VDV200T075R0125C1000 VTV200T075R0125C1000 VDV200T075R0125C1000 VOV200T075R0125C1000 IGZO_DG_BEHAVIORAL_R03_PORTABLE WUM=7.5 LUM=10
XDRV200T075R0125C1000 VOV200T075R0125C1000 VIV200T075R0125C1000 0 0 IGZO_DG_BEHAVIORAL_R03_PORTABLE WUM=60 LUM=10
CLOADV200T075R0125C1000 VOV200T075R0125C1000 0 9.9999999999999998e-13
VDDV200T075R0250C0500 VDV200T075R0250C0500 0 0.20000000000000001
VTPV200T075R0250C0500 VTV200T075R0250C0500 0 0.15000000000000002
VINV200T075R0250C0500 VIV200T075R0250C0500 0 PULSE(0 0.20000000000000001 2.4999999999999999e-07 1e-08 1e-08 6.9999999999999997e-07 1.5e-06)
XLDV200T075R0250C0500 VDV200T075R0250C0500 VTV200T075R0250C0500 VDV200T075R0250C0500 VOV200T075R0250C0500 IGZO_DG_BEHAVIORAL_R03_PORTABLE WUM=15 LUM=10
XDRV200T075R0250C0500 VOV200T075R0250C0500 VIV200T075R0250C0500 0 0 IGZO_DG_BEHAVIORAL_R03_PORTABLE WUM=60 LUM=10
CLOADV200T075R0250C0500 VOV200T075R0250C0500 0 4.9999999999999999e-13
VDDV200T075R0250C1000 VDV200T075R0250C1000 0 0.20000000000000001
VTPV200T075R0250C1000 VTV200T075R0250C1000 0 0.15000000000000002
VINV200T075R0250C1000 VIV200T075R0250C1000 0 PULSE(0 0.20000000000000001 2.4999999999999999e-07 1e-08 1e-08 6.9999999999999997e-07 1.5e-06)
XLDV200T075R0250C1000 VDV200T075R0250C1000 VTV200T075R0250C1000 VDV200T075R0250C1000 VOV200T075R0250C1000 IGZO_DG_BEHAVIORAL_R03_PORTABLE WUM=15 LUM=10
XDRV200T075R0250C1000 VOV200T075R0250C1000 VIV200T075R0250C1000 0 0 IGZO_DG_BEHAVIORAL_R03_PORTABLE WUM=60 LUM=10
CLOADV200T075R0250C1000 VOV200T075R0250C1000 0 9.9999999999999998e-13
VDDV200T075R0500C0500 VDV200T075R0500C0500 0 0.20000000000000001
VTPV200T075R0500C0500 VTV200T075R0500C0500 0 0.15000000000000002
VINV200T075R0500C0500 VIV200T075R0500C0500 0 PULSE(0 0.20000000000000001 2.4999999999999999e-07 1e-08 1e-08 6.9999999999999997e-07 1.5e-06)
XLDV200T075R0500C0500 VDV200T075R0500C0500 VTV200T075R0500C0500 VDV200T075R0500C0500 VOV200T075R0500C0500 IGZO_DG_BEHAVIORAL_R03_PORTABLE WUM=30 LUM=10
XDRV200T075R0500C0500 VOV200T075R0500C0500 VIV200T075R0500C0500 0 0 IGZO_DG_BEHAVIORAL_R03_PORTABLE WUM=60 LUM=10
CLOADV200T075R0500C0500 VOV200T075R0500C0500 0 4.9999999999999999e-13
VDDV200T075R0500C1000 VDV200T075R0500C1000 0 0.20000000000000001
VTPV200T075R0500C1000 VTV200T075R0500C1000 0 0.15000000000000002
VINV200T075R0500C1000 VIV200T075R0500C1000 0 PULSE(0 0.20000000000000001 2.4999999999999999e-07 1e-08 1e-08 6.9999999999999997e-07 1.5e-06)
XLDV200T075R0500C1000 VDV200T075R0500C1000 VTV200T075R0500C1000 VDV200T075R0500C1000 VOV200T075R0500C1000 IGZO_DG_BEHAVIORAL_R03_PORTABLE WUM=30 LUM=10
XDRV200T075R0500C1000 VOV200T075R0500C1000 VIV200T075R0500C1000 0 0 IGZO_DG_BEHAVIORAL_R03_PORTABLE WUM=60 LUM=10
CLOADV200T075R0500C1000 VOV200T075R0500C1000 0 9.9999999999999998e-13
VDDV200T100R0125C0500 VDV200T100R0125C0500 0 0.20000000000000001
VTPV200T100R0125C0500 VTV200T100R0125C0500 0 0.20000000000000001
VINV200T100R0125C0500 VIV200T100R0125C0500 0 PULSE(0 0.20000000000000001 2.4999999999999999e-07 1e-08 1e-08 6.9999999999999997e-07 1.5e-06)
XLDV200T100R0125C0500 VDV200T100R0125C0500 VTV200T100R0125C0500 VDV200T100R0125C0500 VOV200T100R0125C0500 IGZO_DG_BEHAVIORAL_R03_PORTABLE WUM=7.5 LUM=10
XDRV200T100R0125C0500 VOV200T100R0125C0500 VIV200T100R0125C0500 0 0 IGZO_DG_BEHAVIORAL_R03_PORTABLE WUM=60 LUM=10
CLOADV200T100R0125C0500 VOV200T100R0125C0500 0 4.9999999999999999e-13
VDDV200T100R0125C1000 VDV200T100R0125C1000 0 0.20000000000000001
VTPV200T100R0125C1000 VTV200T100R0125C1000 0 0.20000000000000001
VINV200T100R0125C1000 VIV200T100R0125C1000 0 PULSE(0 0.20000000000000001 2.4999999999999999e-07 1e-08 1e-08 6.9999999999999997e-07 1.5e-06)
XLDV200T100R0125C1000 VDV200T100R0125C1000 VTV200T100R0125C1000 VDV200T100R0125C1000 VOV200T100R0125C1000 IGZO_DG_BEHAVIORAL_R03_PORTABLE WUM=7.5 LUM=10
XDRV200T100R0125C1000 VOV200T100R0125C1000 VIV200T100R0125C1000 0 0 IGZO_DG_BEHAVIORAL_R03_PORTABLE WUM=60 LUM=10
CLOADV200T100R0125C1000 VOV200T100R0125C1000 0 9.9999999999999998e-13
VDDV200T100R0250C0500 VDV200T100R0250C0500 0 0.20000000000000001
VTPV200T100R0250C0500 VTV200T100R0250C0500 0 0.20000000000000001
VINV200T100R0250C0500 VIV200T100R0250C0500 0 PULSE(0 0.20000000000000001 2.4999999999999999e-07 1e-08 1e-08 6.9999999999999997e-07 1.5e-06)
XLDV200T100R0250C0500 VDV200T100R0250C0500 VTV200T100R0250C0500 VDV200T100R0250C0500 VOV200T100R0250C0500 IGZO_DG_BEHAVIORAL_R03_PORTABLE WUM=15 LUM=10
XDRV200T100R0250C0500 VOV200T100R0250C0500 VIV200T100R0250C0500 0 0 IGZO_DG_BEHAVIORAL_R03_PORTABLE WUM=60 LUM=10
CLOADV200T100R0250C0500 VOV200T100R0250C0500 0 4.9999999999999999e-13
VDDV200T100R0250C1000 VDV200T100R0250C1000 0 0.20000000000000001
VTPV200T100R0250C1000 VTV200T100R0250C1000 0 0.20000000000000001
VINV200T100R0250C1000 VIV200T100R0250C1000 0 PULSE(0 0.20000000000000001 2.4999999999999999e-07 1e-08 1e-08 6.9999999999999997e-07 1.5e-06)
XLDV200T100R0250C1000 VDV200T100R0250C1000 VTV200T100R0250C1000 VDV200T100R0250C1000 VOV200T100R0250C1000 IGZO_DG_BEHAVIORAL_R03_PORTABLE WUM=15 LUM=10
XDRV200T100R0250C1000 VOV200T100R0250C1000 VIV200T100R0250C1000 0 0 IGZO_DG_BEHAVIORAL_R03_PORTABLE WUM=60 LUM=10
CLOADV200T100R0250C1000 VOV200T100R0250C1000 0 9.9999999999999998e-13
VDDV200T100R0500C0500 VDV200T100R0500C0500 0 0.20000000000000001
VTPV200T100R0500C0500 VTV200T100R0500C0500 0 0.20000000000000001
VINV200T100R0500C0500 VIV200T100R0500C0500 0 PULSE(0 0.20000000000000001 2.4999999999999999e-07 1e-08 1e-08 6.9999999999999997e-07 1.5e-06)
XLDV200T100R0500C0500 VDV200T100R0500C0500 VTV200T100R0500C0500 VDV200T100R0500C0500 VOV200T100R0500C0500 IGZO_DG_BEHAVIORAL_R03_PORTABLE WUM=30 LUM=10
XDRV200T100R0500C0500 VOV200T100R0500C0500 VIV200T100R0500C0500 0 0 IGZO_DG_BEHAVIORAL_R03_PORTABLE WUM=60 LUM=10
CLOADV200T100R0500C0500 VOV200T100R0500C0500 0 4.9999999999999999e-13
VDDV200T100R0500C1000 VDV200T100R0500C1000 0 0.20000000000000001
VTPV200T100R0500C1000 VTV200T100R0500C1000 0 0.20000000000000001
VINV200T100R0500C1000 VIV200T100R0500C1000 0 PULSE(0 0.20000000000000001 2.4999999999999999e-07 1e-08 1e-08 6.9999999999999997e-07 1.5e-06)
XLDV200T100R0500C1000 VDV200T100R0500C1000 VTV200T100R0500C1000 VDV200T100R0500C1000 VOV200T100R0500C1000 IGZO_DG_BEHAVIORAL_R03_PORTABLE WUM=30 LUM=10
XDRV200T100R0500C1000 VOV200T100R0500C1000 VIV200T100R0500C1000 0 0 IGZO_DG_BEHAVIORAL_R03_PORTABLE WUM=60 LUM=10
CLOADV200T100R0500C1000 VOV200T100R0500C1000 0 9.9999999999999998e-13
.TRAN 5.0000000000000001e-09 3.0000000000000001e-06
.save TIME V(VIV100T050R0125C0500) V(VOV100T050R0125C0500) I(VDDV100T050R0125C0500) V(VIV100T050R0125C1000) V(VOV100T050R0125C1000)
+ I(VDDV100T050R0125C1000) V(VIV100T050R0250C0500) V(VOV100T050R0250C0500) I(VDDV100T050R0250C0500) V(VIV100T050R0250C1000) V(VOV100T050R0250C1000)
+ I(VDDV100T050R0250C1000) V(VIV100T050R0500C0500) V(VOV100T050R0500C0500) I(VDDV100T050R0500C0500) V(VIV100T050R0500C1000) V(VOV100T050R0500C1000)
+ I(VDDV100T050R0500C1000) V(VIV100T075R0125C0500) V(VOV100T075R0125C0500) I(VDDV100T075R0125C0500) V(VIV100T075R0125C1000) V(VOV100T075R0125C1000)
+ I(VDDV100T075R0125C1000) V(VIV100T075R0250C0500) V(VOV100T075R0250C0500) I(VDDV100T075R0250C0500) V(VIV100T075R0250C1000) V(VOV100T075R0250C1000)
+ I(VDDV100T075R0250C1000) V(VIV100T075R0500C0500) V(VOV100T075R0500C0500) I(VDDV100T075R0500C0500) V(VIV100T075R0500C1000) V(VOV100T075R0500C1000)
+ I(VDDV100T075R0500C1000) V(VIV100T100R0125C0500) V(VOV100T100R0125C0500) I(VDDV100T100R0125C0500) V(VIV100T100R0125C1000) V(VOV100T100R0125C1000)
+ I(VDDV100T100R0125C1000) V(VIV100T100R0250C0500) V(VOV100T100R0250C0500) I(VDDV100T100R0250C0500) V(VIV100T100R0250C1000) V(VOV100T100R0250C1000)
+ I(VDDV100T100R0250C1000) V(VIV100T100R0500C0500) V(VOV100T100R0500C0500) I(VDDV100T100R0500C0500) V(VIV100T100R0500C1000) V(VOV100T100R0500C1000)
+ I(VDDV100T100R0500C1000) V(VIV200T050R0125C0500) V(VOV200T050R0125C0500) I(VDDV200T050R0125C0500) V(VIV200T050R0125C1000) V(VOV200T050R0125C1000)
+ I(VDDV200T050R0125C1000) V(VIV200T050R0250C0500) V(VOV200T050R0250C0500) I(VDDV200T050R0250C0500) V(VIV200T050R0250C1000) V(VOV200T050R0250C1000)
+ I(VDDV200T050R0250C1000) V(VIV200T050R0500C0500) V(VOV200T050R0500C0500) I(VDDV200T050R0500C0500) V(VIV200T050R0500C1000) V(VOV200T050R0500C1000)
+ I(VDDV200T050R0500C1000) V(VIV200T075R0125C0500) V(VOV200T075R0125C0500) I(VDDV200T075R0125C0500) V(VIV200T075R0125C1000) V(VOV200T075R0125C1000)
+ I(VDDV200T075R0125C1000) V(VIV200T075R0250C0500) V(VOV200T075R0250C0500) I(VDDV200T075R0250C0500) V(VIV200T075R0250C1000) V(VOV200T075R0250C1000)
+ I(VDDV200T075R0250C1000) V(VIV200T075R0500C0500) V(VOV200T075R0500C0500) I(VDDV200T075R0500C0500) V(VIV200T075R0500C1000) V(VOV200T075R0500C1000)
+ I(VDDV200T075R0500C1000) V(VIV200T100R0125C0500) V(VOV200T100R0125C0500) I(VDDV200T100R0125C0500) V(VIV200T100R0125C1000) V(VOV200T100R0125C1000)
+ I(VDDV200T100R0125C1000) V(VIV200T100R0250C0500) V(VOV200T100R0250C0500) I(VDDV200T100R0250C0500) V(VIV200T100R0250C1000) V(VOV200T100R0250C1000)
+ I(VDDV200T100R0250C1000) V(VIV200T100R0500C0500) V(VOV200T100R0500C0500) I(VDDV200T100R0500C0500) V(VIV200T100R0500C1000) V(VOV200T100R0500C1000)
+ I(VDDV200T100R0500C1000)
.control
set filetype=ascii
set plotwinsize=0
run
write results/compact/c00_active_load_inverter_r03/ngspice_tran.raw
quit
.endc
.end
