* C00 R03 ngspice IGZO-only active-load inverter DC
.include spice/models/igzo_dg_behavioral_r03_portable.inc
.option numdgt=17
VSWEEP NORM 0 0
VDDV100T050R0125 VDV100T050R0125 0 0.10000000000000001
VTPV100T050R0125 VTV100T050R0125 0 0.050000000000000003
EINV100T050R0125 VIV100T050R0125 0 NORM 0 0.10000000000000001
XLDV100T050R0125 VDV100T050R0125 VTV100T050R0125 VDV100T050R0125 VOV100T050R0125 IGZO_DG_BEHAVIORAL_R03_PORTABLE WUM=7.5 LUM=10
XDRV100T050R0125 VOV100T050R0125 VIV100T050R0125 0 0 IGZO_DG_BEHAVIORAL_R03_PORTABLE WUM=60 LUM=10
VDDV100T050R0250 VDV100T050R0250 0 0.10000000000000001
VTPV100T050R0250 VTV100T050R0250 0 0.050000000000000003
EINV100T050R0250 VIV100T050R0250 0 NORM 0 0.10000000000000001
XLDV100T050R0250 VDV100T050R0250 VTV100T050R0250 VDV100T050R0250 VOV100T050R0250 IGZO_DG_BEHAVIORAL_R03_PORTABLE WUM=15 LUM=10
XDRV100T050R0250 VOV100T050R0250 VIV100T050R0250 0 0 IGZO_DG_BEHAVIORAL_R03_PORTABLE WUM=60 LUM=10
VDDV100T050R0500 VDV100T050R0500 0 0.10000000000000001
VTPV100T050R0500 VTV100T050R0500 0 0.050000000000000003
EINV100T050R0500 VIV100T050R0500 0 NORM 0 0.10000000000000001
XLDV100T050R0500 VDV100T050R0500 VTV100T050R0500 VDV100T050R0500 VOV100T050R0500 IGZO_DG_BEHAVIORAL_R03_PORTABLE WUM=30 LUM=10
XDRV100T050R0500 VOV100T050R0500 VIV100T050R0500 0 0 IGZO_DG_BEHAVIORAL_R03_PORTABLE WUM=60 LUM=10
VDDV100T075R0125 VDV100T075R0125 0 0.10000000000000001
VTPV100T075R0125 VTV100T075R0125 0 0.075000000000000011
EINV100T075R0125 VIV100T075R0125 0 NORM 0 0.10000000000000001
XLDV100T075R0125 VDV100T075R0125 VTV100T075R0125 VDV100T075R0125 VOV100T075R0125 IGZO_DG_BEHAVIORAL_R03_PORTABLE WUM=7.5 LUM=10
XDRV100T075R0125 VOV100T075R0125 VIV100T075R0125 0 0 IGZO_DG_BEHAVIORAL_R03_PORTABLE WUM=60 LUM=10
VDDV100T075R0250 VDV100T075R0250 0 0.10000000000000001
VTPV100T075R0250 VTV100T075R0250 0 0.075000000000000011
EINV100T075R0250 VIV100T075R0250 0 NORM 0 0.10000000000000001
XLDV100T075R0250 VDV100T075R0250 VTV100T075R0250 VDV100T075R0250 VOV100T075R0250 IGZO_DG_BEHAVIORAL_R03_PORTABLE WUM=15 LUM=10
XDRV100T075R0250 VOV100T075R0250 VIV100T075R0250 0 0 IGZO_DG_BEHAVIORAL_R03_PORTABLE WUM=60 LUM=10
VDDV100T075R0500 VDV100T075R0500 0 0.10000000000000001
VTPV100T075R0500 VTV100T075R0500 0 0.075000000000000011
EINV100T075R0500 VIV100T075R0500 0 NORM 0 0.10000000000000001
XLDV100T075R0500 VDV100T075R0500 VTV100T075R0500 VDV100T075R0500 VOV100T075R0500 IGZO_DG_BEHAVIORAL_R03_PORTABLE WUM=30 LUM=10
XDRV100T075R0500 VOV100T075R0500 VIV100T075R0500 0 0 IGZO_DG_BEHAVIORAL_R03_PORTABLE WUM=60 LUM=10
VDDV100T100R0125 VDV100T100R0125 0 0.10000000000000001
VTPV100T100R0125 VTV100T100R0125 0 0.10000000000000001
EINV100T100R0125 VIV100T100R0125 0 NORM 0 0.10000000000000001
XLDV100T100R0125 VDV100T100R0125 VTV100T100R0125 VDV100T100R0125 VOV100T100R0125 IGZO_DG_BEHAVIORAL_R03_PORTABLE WUM=7.5 LUM=10
XDRV100T100R0125 VOV100T100R0125 VIV100T100R0125 0 0 IGZO_DG_BEHAVIORAL_R03_PORTABLE WUM=60 LUM=10
VDDV100T100R0250 VDV100T100R0250 0 0.10000000000000001
VTPV100T100R0250 VTV100T100R0250 0 0.10000000000000001
EINV100T100R0250 VIV100T100R0250 0 NORM 0 0.10000000000000001
XLDV100T100R0250 VDV100T100R0250 VTV100T100R0250 VDV100T100R0250 VOV100T100R0250 IGZO_DG_BEHAVIORAL_R03_PORTABLE WUM=15 LUM=10
XDRV100T100R0250 VOV100T100R0250 VIV100T100R0250 0 0 IGZO_DG_BEHAVIORAL_R03_PORTABLE WUM=60 LUM=10
VDDV100T100R0500 VDV100T100R0500 0 0.10000000000000001
VTPV100T100R0500 VTV100T100R0500 0 0.10000000000000001
EINV100T100R0500 VIV100T100R0500 0 NORM 0 0.10000000000000001
XLDV100T100R0500 VDV100T100R0500 VTV100T100R0500 VDV100T100R0500 VOV100T100R0500 IGZO_DG_BEHAVIORAL_R03_PORTABLE WUM=30 LUM=10
XDRV100T100R0500 VOV100T100R0500 VIV100T100R0500 0 0 IGZO_DG_BEHAVIORAL_R03_PORTABLE WUM=60 LUM=10
VDDV200T050R0125 VDV200T050R0125 0 0.20000000000000001
VTPV200T050R0125 VTV200T050R0125 0 0.10000000000000001
EINV200T050R0125 VIV200T050R0125 0 NORM 0 0.20000000000000001
XLDV200T050R0125 VDV200T050R0125 VTV200T050R0125 VDV200T050R0125 VOV200T050R0125 IGZO_DG_BEHAVIORAL_R03_PORTABLE WUM=7.5 LUM=10
XDRV200T050R0125 VOV200T050R0125 VIV200T050R0125 0 0 IGZO_DG_BEHAVIORAL_R03_PORTABLE WUM=60 LUM=10
VDDV200T050R0250 VDV200T050R0250 0 0.20000000000000001
VTPV200T050R0250 VTV200T050R0250 0 0.10000000000000001
EINV200T050R0250 VIV200T050R0250 0 NORM 0 0.20000000000000001
XLDV200T050R0250 VDV200T050R0250 VTV200T050R0250 VDV200T050R0250 VOV200T050R0250 IGZO_DG_BEHAVIORAL_R03_PORTABLE WUM=15 LUM=10
XDRV200T050R0250 VOV200T050R0250 VIV200T050R0250 0 0 IGZO_DG_BEHAVIORAL_R03_PORTABLE WUM=60 LUM=10
VDDV200T050R0500 VDV200T050R0500 0 0.20000000000000001
VTPV200T050R0500 VTV200T050R0500 0 0.10000000000000001
EINV200T050R0500 VIV200T050R0500 0 NORM 0 0.20000000000000001
XLDV200T050R0500 VDV200T050R0500 VTV200T050R0500 VDV200T050R0500 VOV200T050R0500 IGZO_DG_BEHAVIORAL_R03_PORTABLE WUM=30 LUM=10
XDRV200T050R0500 VOV200T050R0500 VIV200T050R0500 0 0 IGZO_DG_BEHAVIORAL_R03_PORTABLE WUM=60 LUM=10
VDDV200T075R0125 VDV200T075R0125 0 0.20000000000000001
VTPV200T075R0125 VTV200T075R0125 0 0.15000000000000002
EINV200T075R0125 VIV200T075R0125 0 NORM 0 0.20000000000000001
XLDV200T075R0125 VDV200T075R0125 VTV200T075R0125 VDV200T075R0125 VOV200T075R0125 IGZO_DG_BEHAVIORAL_R03_PORTABLE WUM=7.5 LUM=10
XDRV200T075R0125 VOV200T075R0125 VIV200T075R0125 0 0 IGZO_DG_BEHAVIORAL_R03_PORTABLE WUM=60 LUM=10
VDDV200T075R0250 VDV200T075R0250 0 0.20000000000000001
VTPV200T075R0250 VTV200T075R0250 0 0.15000000000000002
EINV200T075R0250 VIV200T075R0250 0 NORM 0 0.20000000000000001
XLDV200T075R0250 VDV200T075R0250 VTV200T075R0250 VDV200T075R0250 VOV200T075R0250 IGZO_DG_BEHAVIORAL_R03_PORTABLE WUM=15 LUM=10
XDRV200T075R0250 VOV200T075R0250 VIV200T075R0250 0 0 IGZO_DG_BEHAVIORAL_R03_PORTABLE WUM=60 LUM=10
VDDV200T075R0500 VDV200T075R0500 0 0.20000000000000001
VTPV200T075R0500 VTV200T075R0500 0 0.15000000000000002
EINV200T075R0500 VIV200T075R0500 0 NORM 0 0.20000000000000001
XLDV200T075R0500 VDV200T075R0500 VTV200T075R0500 VDV200T075R0500 VOV200T075R0500 IGZO_DG_BEHAVIORAL_R03_PORTABLE WUM=30 LUM=10
XDRV200T075R0500 VOV200T075R0500 VIV200T075R0500 0 0 IGZO_DG_BEHAVIORAL_R03_PORTABLE WUM=60 LUM=10
VDDV200T100R0125 VDV200T100R0125 0 0.20000000000000001
VTPV200T100R0125 VTV200T100R0125 0 0.20000000000000001
EINV200T100R0125 VIV200T100R0125 0 NORM 0 0.20000000000000001
XLDV200T100R0125 VDV200T100R0125 VTV200T100R0125 VDV200T100R0125 VOV200T100R0125 IGZO_DG_BEHAVIORAL_R03_PORTABLE WUM=7.5 LUM=10
XDRV200T100R0125 VOV200T100R0125 VIV200T100R0125 0 0 IGZO_DG_BEHAVIORAL_R03_PORTABLE WUM=60 LUM=10
VDDV200T100R0250 VDV200T100R0250 0 0.20000000000000001
VTPV200T100R0250 VTV200T100R0250 0 0.20000000000000001
EINV200T100R0250 VIV200T100R0250 0 NORM 0 0.20000000000000001
XLDV200T100R0250 VDV200T100R0250 VTV200T100R0250 VDV200T100R0250 VOV200T100R0250 IGZO_DG_BEHAVIORAL_R03_PORTABLE WUM=15 LUM=10
XDRV200T100R0250 VOV200T100R0250 VIV200T100R0250 0 0 IGZO_DG_BEHAVIORAL_R03_PORTABLE WUM=60 LUM=10
VDDV200T100R0500 VDV200T100R0500 0 0.20000000000000001
VTPV200T100R0500 VTV200T100R0500 0 0.20000000000000001
EINV200T100R0500 VIV200T100R0500 0 NORM 0 0.20000000000000001
XLDV200T100R0500 VDV200T100R0500 VTV200T100R0500 VDV200T100R0500 VOV200T100R0500 IGZO_DG_BEHAVIORAL_R03_PORTABLE WUM=30 LUM=10
XDRV200T100R0500 VOV200T100R0500 VIV200T100R0500 0 0 IGZO_DG_BEHAVIORAL_R03_PORTABLE WUM=60 LUM=10
.DC VSWEEP 0 1 0.01
.save V(NORM) V(VOV100T050R0125) I(VDDV100T050R0125) V(VOV100T050R0250) I(VDDV100T050R0250) V(VOV100T050R0500)
+ I(VDDV100T050R0500) V(VOV100T075R0125) I(VDDV100T075R0125) V(VOV100T075R0250) I(VDDV100T075R0250) V(VOV100T075R0500)
+ I(VDDV100T075R0500) V(VOV100T100R0125) I(VDDV100T100R0125) V(VOV100T100R0250) I(VDDV100T100R0250) V(VOV100T100R0500)
+ I(VDDV100T100R0500) V(VOV200T050R0125) I(VDDV200T050R0125) V(VOV200T050R0250) I(VDDV200T050R0250) V(VOV200T050R0500)
+ I(VDDV200T050R0500) V(VOV200T075R0125) I(VDDV200T075R0125) V(VOV200T075R0250) I(VDDV200T075R0250) V(VOV200T075R0500)
+ I(VDDV200T075R0500) V(VOV200T100R0125) I(VDDV200T100R0125) V(VOV200T100R0250) I(VDDV200T100R0250) V(VOV200T100R0500)
+ I(VDDV200T100R0500)
.control
set filetype=ascii
run
write results/compact/c00_active_load_inverter_r03/ngspice_dc.raw
quit
.endc
.end
