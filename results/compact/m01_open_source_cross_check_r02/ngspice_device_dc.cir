* M01 R02 ngspice IGZO-only device DC
.include "spice/models/igzo_dg_behavioral_r02.inc"
.option numdgt=17
VSWEEP SWEEP 0 0
VDS000 D000 0 0.01
VTG000 TG000 0 0
VBG000 BG000 0 -1
XDEV000 D000 TG000 BG000 0 IGZO_DG_BEHAVIORAL_R02 WUM=60 LUM=10
VDS001 D001 0 0.01
VTG001 TG001 0 0
VBG001 BG001 0 -0.75
XDEV001 D001 TG001 BG001 0 IGZO_DG_BEHAVIORAL_R02 WUM=60 LUM=10
VDS002 D002 0 0.01
VTG002 TG002 0 0
VBG002 BG002 0 -0.5
XDEV002 D002 TG002 BG002 0 IGZO_DG_BEHAVIORAL_R02 WUM=60 LUM=10
VDS003 D003 0 0.01
VTG003 TG003 0 0
VBG003 BG003 0 -0.47499999999999998
XDEV003 D003 TG003 BG003 0 IGZO_DG_BEHAVIORAL_R02 WUM=60 LUM=10
VDS004 D004 0 0.01
VTG004 TG004 0 0
VBG004 BG004 0 -0.45000000000000001
XDEV004 D004 TG004 BG004 0 IGZO_DG_BEHAVIORAL_R02 WUM=60 LUM=10
VDS005 D005 0 0.01
VTG005 TG005 0 0
VBG005 BG005 0 -0.42499999999999999
XDEV005 D005 TG005 BG005 0 IGZO_DG_BEHAVIORAL_R02 WUM=60 LUM=10
VDS006 D006 0 0.01
VTG006 TG006 0 0
VBG006 BG006 0 -0.40000000000000002
XDEV006 D006 TG006 BG006 0 IGZO_DG_BEHAVIORAL_R02 WUM=60 LUM=10
VDS007 D007 0 0.01
VTG007 TG007 0 0
VBG007 BG007 0 -0.375
XDEV007 D007 TG007 BG007 0 IGZO_DG_BEHAVIORAL_R02 WUM=60 LUM=10
VDS008 D008 0 0.01
VTG008 TG008 0 0
VBG008 BG008 0 -0.34999999999999998
XDEV008 D008 TG008 BG008 0 IGZO_DG_BEHAVIORAL_R02 WUM=60 LUM=10
VDS009 D009 0 0.01
VTG009 TG009 0 0
VBG009 BG009 0 -0.32500000000000001
XDEV009 D009 TG009 BG009 0 IGZO_DG_BEHAVIORAL_R02 WUM=60 LUM=10
VDS010 D010 0 0.01
VTG010 TG010 0 0
VBG010 BG010 0 -0.29999999999999999
XDEV010 D010 TG010 BG010 0 IGZO_DG_BEHAVIORAL_R02 WUM=60 LUM=10
VDS011 D011 0 0.01
VTG011 TG011 0 0
VBG011 BG011 0 -0.27500000000000002
XDEV011 D011 TG011 BG011 0 IGZO_DG_BEHAVIORAL_R02 WUM=60 LUM=10
VDS012 D012 0 0.01
VTG012 TG012 0 0
VBG012 BG012 0 -0.25
XDEV012 D012 TG012 BG012 0 IGZO_DG_BEHAVIORAL_R02 WUM=60 LUM=10
VDS013 D013 0 0.01
VTG013 TG013 0 0
VBG013 BG013 0 -0.22500000000000001
XDEV013 D013 TG013 BG013 0 IGZO_DG_BEHAVIORAL_R02 WUM=60 LUM=10
VDS014 D014 0 0.01
VTG014 TG014 0 0
VBG014 BG014 0 -0.20000000000000001
XDEV014 D014 TG014 BG014 0 IGZO_DG_BEHAVIORAL_R02 WUM=60 LUM=10
VDS015 D015 0 0.01
VTG015 TG015 0 0
VBG015 BG015 0 -0.17499999999999999
XDEV015 D015 TG015 BG015 0 IGZO_DG_BEHAVIORAL_R02 WUM=60 LUM=10
VDS016 D016 0 0.01
VTG016 TG016 0 0
VBG016 BG016 0 -0.14999999999999999
XDEV016 D016 TG016 BG016 0 IGZO_DG_BEHAVIORAL_R02 WUM=60 LUM=10
VDS017 D017 0 0.01
VTG017 TG017 0 0
VBG017 BG017 0 -0.125
XDEV017 D017 TG017 BG017 0 IGZO_DG_BEHAVIORAL_R02 WUM=60 LUM=10
VDS018 D018 0 0.01
VTG018 TG018 0 0
VBG018 BG018 0 -0.10000000000000001
XDEV018 D018 TG018 BG018 0 IGZO_DG_BEHAVIORAL_R02 WUM=60 LUM=10
VDS019 D019 0 0.01
VTG019 TG019 0 0
VBG019 BG019 0 -0.074999999999999997
XDEV019 D019 TG019 BG019 0 IGZO_DG_BEHAVIORAL_R02 WUM=60 LUM=10
VDS020 D020 0 0.01
VTG020 TG020 0 0
VBG020 BG020 0 -0.050000000000000003
XDEV020 D020 TG020 BG020 0 IGZO_DG_BEHAVIORAL_R02 WUM=60 LUM=10
VDS021 D021 0 0.01
VTG021 TG021 0 0
VBG021 BG021 0 -0.025000000000000001
XDEV021 D021 TG021 BG021 0 IGZO_DG_BEHAVIORAL_R02 WUM=60 LUM=10
VDS022 D022 0 0.01
VTG022 TG022 0 0
VBG022 BG022 0 0
XDEV022 D022 TG022 BG022 0 IGZO_DG_BEHAVIORAL_R02 WUM=60 LUM=10
VDS023 D023 0 0.01
VTG023 TG023 0 0
VBG023 BG023 0 0.025000000000000001
XDEV023 D023 TG023 BG023 0 IGZO_DG_BEHAVIORAL_R02 WUM=60 LUM=10
VDS024 D024 0 0.01
VTG024 TG024 0 0
VBG024 BG024 0 0.050000000000000003
XDEV024 D024 TG024 BG024 0 IGZO_DG_BEHAVIORAL_R02 WUM=60 LUM=10
VDS025 D025 0 0.01
VTG025 TG025 0 0
VBG025 BG025 0 0.074999999999999997
XDEV025 D025 TG025 BG025 0 IGZO_DG_BEHAVIORAL_R02 WUM=60 LUM=10
VDS026 D026 0 0.01
VTG026 TG026 0 0
VBG026 BG026 0 0.10000000000000001
XDEV026 D026 TG026 BG026 0 IGZO_DG_BEHAVIORAL_R02 WUM=60 LUM=10
VDS027 D027 0 0.01
VTG027 TG027 0 0
VBG027 BG027 0 0.125
XDEV027 D027 TG027 BG027 0 IGZO_DG_BEHAVIORAL_R02 WUM=60 LUM=10
VDS028 D028 0 0.01
VTG028 TG028 0 0
VBG028 BG028 0 0.14999999999999999
XDEV028 D028 TG028 BG028 0 IGZO_DG_BEHAVIORAL_R02 WUM=60 LUM=10
VDS029 D029 0 0.01
VTG029 TG029 0 0
VBG029 BG029 0 0.17499999999999999
XDEV029 D029 TG029 BG029 0 IGZO_DG_BEHAVIORAL_R02 WUM=60 LUM=10
VDS030 D030 0 0.01
VTG030 TG030 0 0
VBG030 BG030 0 0.20000000000000001
XDEV030 D030 TG030 BG030 0 IGZO_DG_BEHAVIORAL_R02 WUM=60 LUM=10
VDS031 D031 0 0.01
VTG031 TG031 0 0
VBG031 BG031 0 0.22500000000000001
XDEV031 D031 TG031 BG031 0 IGZO_DG_BEHAVIORAL_R02 WUM=60 LUM=10
VDS032 D032 0 0.01
VTG032 TG032 0 0
VBG032 BG032 0 0.25
XDEV032 D032 TG032 BG032 0 IGZO_DG_BEHAVIORAL_R02 WUM=60 LUM=10
VDS033 D033 0 0.01
VTG033 TG033 0 0
VBG033 BG033 0 0.27500000000000002
XDEV033 D033 TG033 BG033 0 IGZO_DG_BEHAVIORAL_R02 WUM=60 LUM=10
VDS034 D034 0 0.01
VTG034 TG034 0 0
VBG034 BG034 0 0.29999999999999999
XDEV034 D034 TG034 BG034 0 IGZO_DG_BEHAVIORAL_R02 WUM=60 LUM=10
VDS035 D035 0 0.01
VTG035 TG035 0 0
VBG035 BG035 0 0.32500000000000001
XDEV035 D035 TG035 BG035 0 IGZO_DG_BEHAVIORAL_R02 WUM=60 LUM=10
VDS036 D036 0 0.01
VTG036 TG036 0 0
VBG036 BG036 0 0.34999999999999998
XDEV036 D036 TG036 BG036 0 IGZO_DG_BEHAVIORAL_R02 WUM=60 LUM=10
VDS037 D037 0 0.01
VTG037 TG037 0 0
VBG037 BG037 0 0.375
XDEV037 D037 TG037 BG037 0 IGZO_DG_BEHAVIORAL_R02 WUM=60 LUM=10
VDS038 D038 0 0.01
VTG038 TG038 0 0
VBG038 BG038 0 0.40000000000000002
XDEV038 D038 TG038 BG038 0 IGZO_DG_BEHAVIORAL_R02 WUM=60 LUM=10
VDS039 D039 0 0.01
VTG039 TG039 0 0
VBG039 BG039 0 0.42499999999999999
XDEV039 D039 TG039 BG039 0 IGZO_DG_BEHAVIORAL_R02 WUM=60 LUM=10
VDS040 D040 0 0.01
VTG040 TG040 0 0
VBG040 BG040 0 0.45000000000000001
XDEV040 D040 TG040 BG040 0 IGZO_DG_BEHAVIORAL_R02 WUM=60 LUM=10
VDS041 D041 0 0.01
VTG041 TG041 0 0
VBG041 BG041 0 0.47499999999999998
XDEV041 D041 TG041 BG041 0 IGZO_DG_BEHAVIORAL_R02 WUM=60 LUM=10
VDS042 D042 0 0.01
VTG042 TG042 0 0
VBG042 BG042 0 0.5
XDEV042 D042 TG042 BG042 0 IGZO_DG_BEHAVIORAL_R02 WUM=60 LUM=10
VDS043 D043 0 0.01
VTG043 TG043 0 0
VBG043 BG043 0 0.52500000000000002
XDEV043 D043 TG043 BG043 0 IGZO_DG_BEHAVIORAL_R02 WUM=60 LUM=10
VDS044 D044 0 0.01
VTG044 TG044 0 0
VBG044 BG044 0 0.55000000000000004
XDEV044 D044 TG044 BG044 0 IGZO_DG_BEHAVIORAL_R02 WUM=60 LUM=10
VDS045 D045 0 0.01
VTG045 TG045 0 0
VBG045 BG045 0 0.57499999999999996
XDEV045 D045 TG045 BG045 0 IGZO_DG_BEHAVIORAL_R02 WUM=60 LUM=10
VDS046 D046 0 0.01
VTG046 TG046 0 0
VBG046 BG046 0 0.59999999999999998
XDEV046 D046 TG046 BG046 0 IGZO_DG_BEHAVIORAL_R02 WUM=60 LUM=10
VDS047 D047 0 0.01
VTG047 TG047 0 0
VBG047 BG047 0 0.69999999999999996
XDEV047 D047 TG047 BG047 0 IGZO_DG_BEHAVIORAL_R02 WUM=60 LUM=10
VDS048 D048 0 0.01
VTG048 TG048 0 0
VBG048 BG048 0 0.80000000000000004
XDEV048 D048 TG048 BG048 0 IGZO_DG_BEHAVIORAL_R02 WUM=60 LUM=10
VDS049 D049 0 0.01
VTG049 TG049 0 0
VBG049 BG049 0 0.90000000000000002
XDEV049 D049 TG049 BG049 0 IGZO_DG_BEHAVIORAL_R02 WUM=60 LUM=10
VDS050 D050 0 0.01
VTG050 TG050 0 0
VBG050 BG050 0 1
XDEV050 D050 TG050 BG050 0 IGZO_DG_BEHAVIORAL_R02 WUM=60 LUM=10
VDS051 D051 0 0
VTG051 TG051 0 0
VBG051 BG051 0 0
XDEV051 D051 TG051 BG051 0 IGZO_DG_BEHAVIORAL_R02 WUM=60 LUM=10
VDS052 D052 0 0.01
VTG052 TG052 0 0
VBG052 BG052 0 0
XDEV052 D052 TG052 BG052 0 IGZO_DG_BEHAVIORAL_R02 WUM=60 LUM=10
VDS053 D053 0 0.050000000000000003
VTG053 TG053 0 0
VBG053 BG053 0 0
XDEV053 D053 TG053 BG053 0 IGZO_DG_BEHAVIORAL_R02 WUM=60 LUM=10
VDS054 D054 0 0.10000000000000001
VTG054 TG054 0 0
VBG054 BG054 0 0
XDEV054 D054 TG054 BG054 0 IGZO_DG_BEHAVIORAL_R02 WUM=60 LUM=10
VDS055 D055 0 0.20000000000000001
VTG055 TG055 0 0
VBG055 BG055 0 0
XDEV055 D055 TG055 BG055 0 IGZO_DG_BEHAVIORAL_R02 WUM=60 LUM=10
VDS056 D056 0 0
VTG056 TG056 0 0
VBG056 BG056 0 0.5
XDEV056 D056 TG056 BG056 0 IGZO_DG_BEHAVIORAL_R02 WUM=60 LUM=10
VDS057 D057 0 0.01
VTG057 TG057 0 0
VBG057 BG057 0 0.5
XDEV057 D057 TG057 BG057 0 IGZO_DG_BEHAVIORAL_R02 WUM=60 LUM=10
VDS058 D058 0 0.050000000000000003
VTG058 TG058 0 0
VBG058 BG058 0 0.5
XDEV058 D058 TG058 BG058 0 IGZO_DG_BEHAVIORAL_R02 WUM=60 LUM=10
VDS059 D059 0 0.10000000000000001
VTG059 TG059 0 0
VBG059 BG059 0 0.5
XDEV059 D059 TG059 BG059 0 IGZO_DG_BEHAVIORAL_R02 WUM=60 LUM=10
VDS060 D060 0 0.20000000000000001
VTG060 TG060 0 0
VBG060 BG060 0 0.5
XDEV060 D060 TG060 BG060 0 IGZO_DG_BEHAVIORAL_R02 WUM=60 LUM=10
VDS061 D061 0 0
VTG061 TG061 0 0
VBG061 BG061 0 1
XDEV061 D061 TG061 BG061 0 IGZO_DG_BEHAVIORAL_R02 WUM=60 LUM=10
VDS062 D062 0 0.01
VTG062 TG062 0 0
VBG062 BG062 0 1
XDEV062 D062 TG062 BG062 0 IGZO_DG_BEHAVIORAL_R02 WUM=60 LUM=10
VDS063 D063 0 0.050000000000000003
VTG063 TG063 0 0
VBG063 BG063 0 1
XDEV063 D063 TG063 BG063 0 IGZO_DG_BEHAVIORAL_R02 WUM=60 LUM=10
VDS064 D064 0 0.10000000000000001
VTG064 TG064 0 0
VBG064 BG064 0 1
XDEV064 D064 TG064 BG064 0 IGZO_DG_BEHAVIORAL_R02 WUM=60 LUM=10
VDS065 D065 0 0.20000000000000001
VTG065 TG065 0 0
VBG065 BG065 0 1
XDEV065 D065 TG065 BG065 0 IGZO_DG_BEHAVIORAL_R02 WUM=60 LUM=10
VDS066 D066 0 0.01
VTG066 TG066 0 -0.5
VBG066 BG066 0 -0.29999999999999999
XDEV066 D066 TG066 BG066 0 IGZO_DG_BEHAVIORAL_R02 WUM=60 LUM=10
VDS067 D067 0 0.01
VTG067 TG067 0 -0.45000000000000001
VBG067 BG067 0 -0.29999999999999999
XDEV067 D067 TG067 BG067 0 IGZO_DG_BEHAVIORAL_R02 WUM=60 LUM=10
VDS068 D068 0 0.01
VTG068 TG068 0 -0.40000000000000002
VBG068 BG068 0 -0.29999999999999999
XDEV068 D068 TG068 BG068 0 IGZO_DG_BEHAVIORAL_R02 WUM=60 LUM=10
VDS069 D069 0 0.01
VTG069 TG069 0 -0.34999999999999998
VBG069 BG069 0 -0.29999999999999999
XDEV069 D069 TG069 BG069 0 IGZO_DG_BEHAVIORAL_R02 WUM=60 LUM=10
VDS070 D070 0 0.01
VTG070 TG070 0 -0.29999999999999999
VBG070 BG070 0 -0.29999999999999999
XDEV070 D070 TG070 BG070 0 IGZO_DG_BEHAVIORAL_R02 WUM=60 LUM=10
VDS071 D071 0 0.01
VTG071 TG071 0 -0.25
VBG071 BG071 0 -0.29999999999999999
XDEV071 D071 TG071 BG071 0 IGZO_DG_BEHAVIORAL_R02 WUM=60 LUM=10
VDS072 D072 0 0.01
VTG072 TG072 0 -0.20000000000000001
VBG072 BG072 0 -0.29999999999999999
XDEV072 D072 TG072 BG072 0 IGZO_DG_BEHAVIORAL_R02 WUM=60 LUM=10
VDS073 D073 0 0.01
VTG073 TG073 0 -0.14999999999999999
VBG073 BG073 0 -0.29999999999999999
XDEV073 D073 TG073 BG073 0 IGZO_DG_BEHAVIORAL_R02 WUM=60 LUM=10
VDS074 D074 0 0.01
VTG074 TG074 0 -0.10000000000000001
VBG074 BG074 0 -0.29999999999999999
XDEV074 D074 TG074 BG074 0 IGZO_DG_BEHAVIORAL_R02 WUM=60 LUM=10
VDS075 D075 0 0.01
VTG075 TG075 0 -0.050000000000000003
VBG075 BG075 0 -0.29999999999999999
XDEV075 D075 TG075 BG075 0 IGZO_DG_BEHAVIORAL_R02 WUM=60 LUM=10
VDS076 D076 0 0.01
VTG076 TG076 0 0
VBG076 BG076 0 -0.29999999999999999
XDEV076 D076 TG076 BG076 0 IGZO_DG_BEHAVIORAL_R02 WUM=60 LUM=10
VDS077 D077 0 0.01
VTG077 TG077 0 0.050000000000000003
VBG077 BG077 0 -0.29999999999999999
XDEV077 D077 TG077 BG077 0 IGZO_DG_BEHAVIORAL_R02 WUM=60 LUM=10
VDS078 D078 0 0.01
VTG078 TG078 0 0.10000000000000001
VBG078 BG078 0 -0.29999999999999999
XDEV078 D078 TG078 BG078 0 IGZO_DG_BEHAVIORAL_R02 WUM=60 LUM=10
VDS079 D079 0 0.01
VTG079 TG079 0 0.14999999999999999
VBG079 BG079 0 -0.29999999999999999
XDEV079 D079 TG079 BG079 0 IGZO_DG_BEHAVIORAL_R02 WUM=60 LUM=10
VDS080 D080 0 0.01
VTG080 TG080 0 0.20000000000000001
VBG080 BG080 0 -0.29999999999999999
XDEV080 D080 TG080 BG080 0 IGZO_DG_BEHAVIORAL_R02 WUM=60 LUM=10
VDS081 D081 0 0.01
VTG081 TG081 0 0.25
VBG081 BG081 0 -0.29999999999999999
XDEV081 D081 TG081 BG081 0 IGZO_DG_BEHAVIORAL_R02 WUM=60 LUM=10
VDS082 D082 0 0.01
VTG082 TG082 0 0.29999999999999999
VBG082 BG082 0 -0.29999999999999999
XDEV082 D082 TG082 BG082 0 IGZO_DG_BEHAVIORAL_R02 WUM=60 LUM=10
VDS083 D083 0 0.01
VTG083 TG083 0 0.34999999999999998
VBG083 BG083 0 -0.29999999999999999
XDEV083 D083 TG083 BG083 0 IGZO_DG_BEHAVIORAL_R02 WUM=60 LUM=10
VDS084 D084 0 0.01
VTG084 TG084 0 0.40000000000000002
VBG084 BG084 0 -0.29999999999999999
XDEV084 D084 TG084 BG084 0 IGZO_DG_BEHAVIORAL_R02 WUM=60 LUM=10
VDS085 D085 0 0.01
VTG085 TG085 0 0.45000000000000001
VBG085 BG085 0 -0.29999999999999999
XDEV085 D085 TG085 BG085 0 IGZO_DG_BEHAVIORAL_R02 WUM=60 LUM=10
VDS086 D086 0 0.01
VTG086 TG086 0 0.5
VBG086 BG086 0 -0.29999999999999999
XDEV086 D086 TG086 BG086 0 IGZO_DG_BEHAVIORAL_R02 WUM=60 LUM=10
VDS087 D087 0 0.01
VTG087 TG087 0 0.55000000000000004
VBG087 BG087 0 -0.29999999999999999
XDEV087 D087 TG087 BG087 0 IGZO_DG_BEHAVIORAL_R02 WUM=60 LUM=10
VDS088 D088 0 0.01
VTG088 TG088 0 0.59999999999999998
VBG088 BG088 0 -0.29999999999999999
XDEV088 D088 TG088 BG088 0 IGZO_DG_BEHAVIORAL_R02 WUM=60 LUM=10
VDS089 D089 0 0.01
VTG089 TG089 0 0.65000000000000002
VBG089 BG089 0 -0.29999999999999999
XDEV089 D089 TG089 BG089 0 IGZO_DG_BEHAVIORAL_R02 WUM=60 LUM=10
VDS090 D090 0 0.01
VTG090 TG090 0 0.69999999999999996
VBG090 BG090 0 -0.29999999999999999
XDEV090 D090 TG090 BG090 0 IGZO_DG_BEHAVIORAL_R02 WUM=60 LUM=10
VDS091 D091 0 0.01
VTG091 TG091 0 0.75
VBG091 BG091 0 -0.29999999999999999
XDEV091 D091 TG091 BG091 0 IGZO_DG_BEHAVIORAL_R02 WUM=60 LUM=10
VDS092 D092 0 0.01
VTG092 TG092 0 0.80000000000000004
VBG092 BG092 0 -0.29999999999999999
XDEV092 D092 TG092 BG092 0 IGZO_DG_BEHAVIORAL_R02 WUM=60 LUM=10
VDS093 D093 0 0.01
VTG093 TG093 0 0.84999999999999998
VBG093 BG093 0 -0.29999999999999999
XDEV093 D093 TG093 BG093 0 IGZO_DG_BEHAVIORAL_R02 WUM=60 LUM=10
VDS094 D094 0 0.01
VTG094 TG094 0 0.90000000000000002
VBG094 BG094 0 -0.29999999999999999
XDEV094 D094 TG094 BG094 0 IGZO_DG_BEHAVIORAL_R02 WUM=60 LUM=10
VDS095 D095 0 0.01
VTG095 TG095 0 0.94999999999999996
VBG095 BG095 0 -0.29999999999999999
XDEV095 D095 TG095 BG095 0 IGZO_DG_BEHAVIORAL_R02 WUM=60 LUM=10
VDS096 D096 0 0.01
VTG096 TG096 0 1
VBG096 BG096 0 -0.29999999999999999
XDEV096 D096 TG096 BG096 0 IGZO_DG_BEHAVIORAL_R02 WUM=60 LUM=10
VDS097 D097 0 0.01
VTG097 TG097 0 -0.5
VBG097 BG097 0 0.29999999999999999
XDEV097 D097 TG097 BG097 0 IGZO_DG_BEHAVIORAL_R02 WUM=60 LUM=10
VDS098 D098 0 0.01
VTG098 TG098 0 -0.45000000000000001
VBG098 BG098 0 0.29999999999999999
XDEV098 D098 TG098 BG098 0 IGZO_DG_BEHAVIORAL_R02 WUM=60 LUM=10
VDS099 D099 0 0.01
VTG099 TG099 0 -0.40000000000000002
VBG099 BG099 0 0.29999999999999999
XDEV099 D099 TG099 BG099 0 IGZO_DG_BEHAVIORAL_R02 WUM=60 LUM=10
VDS100 D100 0 0.01
VTG100 TG100 0 -0.34999999999999998
VBG100 BG100 0 0.29999999999999999
XDEV100 D100 TG100 BG100 0 IGZO_DG_BEHAVIORAL_R02 WUM=60 LUM=10
VDS101 D101 0 0.01
VTG101 TG101 0 -0.29999999999999999
VBG101 BG101 0 0.29999999999999999
XDEV101 D101 TG101 BG101 0 IGZO_DG_BEHAVIORAL_R02 WUM=60 LUM=10
VDS102 D102 0 0.01
VTG102 TG102 0 -0.25
VBG102 BG102 0 0.29999999999999999
XDEV102 D102 TG102 BG102 0 IGZO_DG_BEHAVIORAL_R02 WUM=60 LUM=10
VDS103 D103 0 0.01
VTG103 TG103 0 -0.20000000000000001
VBG103 BG103 0 0.29999999999999999
XDEV103 D103 TG103 BG103 0 IGZO_DG_BEHAVIORAL_R02 WUM=60 LUM=10
VDS104 D104 0 0.01
VTG104 TG104 0 -0.14999999999999999
VBG104 BG104 0 0.29999999999999999
XDEV104 D104 TG104 BG104 0 IGZO_DG_BEHAVIORAL_R02 WUM=60 LUM=10
VDS105 D105 0 0.01
VTG105 TG105 0 -0.10000000000000001
VBG105 BG105 0 0.29999999999999999
XDEV105 D105 TG105 BG105 0 IGZO_DG_BEHAVIORAL_R02 WUM=60 LUM=10
VDS106 D106 0 0.01
VTG106 TG106 0 -0.050000000000000003
VBG106 BG106 0 0.29999999999999999
XDEV106 D106 TG106 BG106 0 IGZO_DG_BEHAVIORAL_R02 WUM=60 LUM=10
VDS107 D107 0 0.01
VTG107 TG107 0 0
VBG107 BG107 0 0.29999999999999999
XDEV107 D107 TG107 BG107 0 IGZO_DG_BEHAVIORAL_R02 WUM=60 LUM=10
VDS108 D108 0 0.01
VTG108 TG108 0 0.050000000000000003
VBG108 BG108 0 0.29999999999999999
XDEV108 D108 TG108 BG108 0 IGZO_DG_BEHAVIORAL_R02 WUM=60 LUM=10
VDS109 D109 0 0.01
VTG109 TG109 0 0.10000000000000001
VBG109 BG109 0 0.29999999999999999
XDEV109 D109 TG109 BG109 0 IGZO_DG_BEHAVIORAL_R02 WUM=60 LUM=10
VDS110 D110 0 0.01
VTG110 TG110 0 0.14999999999999999
VBG110 BG110 0 0.29999999999999999
XDEV110 D110 TG110 BG110 0 IGZO_DG_BEHAVIORAL_R02 WUM=60 LUM=10
VDS111 D111 0 0.01
VTG111 TG111 0 0.20000000000000001
VBG111 BG111 0 0.29999999999999999
XDEV111 D111 TG111 BG111 0 IGZO_DG_BEHAVIORAL_R02 WUM=60 LUM=10
VDS112 D112 0 0.01
VTG112 TG112 0 0.25
VBG112 BG112 0 0.29999999999999999
XDEV112 D112 TG112 BG112 0 IGZO_DG_BEHAVIORAL_R02 WUM=60 LUM=10
VDS113 D113 0 0.01
VTG113 TG113 0 0.29999999999999999
VBG113 BG113 0 0.29999999999999999
XDEV113 D113 TG113 BG113 0 IGZO_DG_BEHAVIORAL_R02 WUM=60 LUM=10
VDS114 D114 0 0.01
VTG114 TG114 0 0.34999999999999998
VBG114 BG114 0 0.29999999999999999
XDEV114 D114 TG114 BG114 0 IGZO_DG_BEHAVIORAL_R02 WUM=60 LUM=10
VDS115 D115 0 0.01
VTG115 TG115 0 0.40000000000000002
VBG115 BG115 0 0.29999999999999999
XDEV115 D115 TG115 BG115 0 IGZO_DG_BEHAVIORAL_R02 WUM=60 LUM=10
VDS116 D116 0 0.01
VTG116 TG116 0 0.45000000000000001
VBG116 BG116 0 0.29999999999999999
XDEV116 D116 TG116 BG116 0 IGZO_DG_BEHAVIORAL_R02 WUM=60 LUM=10
VDS117 D117 0 0.01
VTG117 TG117 0 0.5
VBG117 BG117 0 0.29999999999999999
XDEV117 D117 TG117 BG117 0 IGZO_DG_BEHAVIORAL_R02 WUM=60 LUM=10
VDS118 D118 0 0.01
VTG118 TG118 0 0.55000000000000004
VBG118 BG118 0 0.29999999999999999
XDEV118 D118 TG118 BG118 0 IGZO_DG_BEHAVIORAL_R02 WUM=60 LUM=10
VDS119 D119 0 0.01
VTG119 TG119 0 0.59999999999999998
VBG119 BG119 0 0.29999999999999999
XDEV119 D119 TG119 BG119 0 IGZO_DG_BEHAVIORAL_R02 WUM=60 LUM=10
VDS120 D120 0 0.01
VTG120 TG120 0 0.65000000000000002
VBG120 BG120 0 0.29999999999999999
XDEV120 D120 TG120 BG120 0 IGZO_DG_BEHAVIORAL_R02 WUM=60 LUM=10
VDS121 D121 0 0.01
VTG121 TG121 0 0.69999999999999996
VBG121 BG121 0 0.29999999999999999
XDEV121 D121 TG121 BG121 0 IGZO_DG_BEHAVIORAL_R02 WUM=60 LUM=10
VDS122 D122 0 0.01
VTG122 TG122 0 0.75
VBG122 BG122 0 0.29999999999999999
XDEV122 D122 TG122 BG122 0 IGZO_DG_BEHAVIORAL_R02 WUM=60 LUM=10
VDS123 D123 0 0.01
VTG123 TG123 0 0.80000000000000004
VBG123 BG123 0 0.29999999999999999
XDEV123 D123 TG123 BG123 0 IGZO_DG_BEHAVIORAL_R02 WUM=60 LUM=10
VDS124 D124 0 0.01
VTG124 TG124 0 0.84999999999999998
VBG124 BG124 0 0.29999999999999999
XDEV124 D124 TG124 BG124 0 IGZO_DG_BEHAVIORAL_R02 WUM=60 LUM=10
VDS125 D125 0 0.01
VTG125 TG125 0 0.90000000000000002
VBG125 BG125 0 0.29999999999999999
XDEV125 D125 TG125 BG125 0 IGZO_DG_BEHAVIORAL_R02 WUM=60 LUM=10
VDS126 D126 0 0.01
VTG126 TG126 0 0.94999999999999996
VBG126 BG126 0 0.29999999999999999
XDEV126 D126 TG126 BG126 0 IGZO_DG_BEHAVIORAL_R02 WUM=60 LUM=10
VDS127 D127 0 0.01
VTG127 TG127 0 1
VBG127 BG127 0 0.29999999999999999
XDEV127 D127 TG127 BG127 0 IGZO_DG_BEHAVIORAL_R02 WUM=60 LUM=10
VDS128 D128 0 0.01
VTG128 TG128 0 -0.5
VBG128 BG128 0 0
XDEV128 D128 TG128 BG128 0 IGZO_DG_BEHAVIORAL_R02 WUM=60 LUM=8
VDS129 D129 0 0.01
VTG129 TG129 0 -0.45000000000000001
VBG129 BG129 0 0
XDEV129 D129 TG129 BG129 0 IGZO_DG_BEHAVIORAL_R02 WUM=60 LUM=8
VDS130 D130 0 0.01
VTG130 TG130 0 -0.40000000000000002
VBG130 BG130 0 0
XDEV130 D130 TG130 BG130 0 IGZO_DG_BEHAVIORAL_R02 WUM=60 LUM=8
VDS131 D131 0 0.01
VTG131 TG131 0 -0.34999999999999998
VBG131 BG131 0 0
XDEV131 D131 TG131 BG131 0 IGZO_DG_BEHAVIORAL_R02 WUM=60 LUM=8
VDS132 D132 0 0.01
VTG132 TG132 0 -0.29999999999999999
VBG132 BG132 0 0
XDEV132 D132 TG132 BG132 0 IGZO_DG_BEHAVIORAL_R02 WUM=60 LUM=8
VDS133 D133 0 0.01
VTG133 TG133 0 -0.25
VBG133 BG133 0 0
XDEV133 D133 TG133 BG133 0 IGZO_DG_BEHAVIORAL_R02 WUM=60 LUM=8
VDS134 D134 0 0.01
VTG134 TG134 0 -0.20000000000000001
VBG134 BG134 0 0
XDEV134 D134 TG134 BG134 0 IGZO_DG_BEHAVIORAL_R02 WUM=60 LUM=8
VDS135 D135 0 0.01
VTG135 TG135 0 -0.14999999999999999
VBG135 BG135 0 0
XDEV135 D135 TG135 BG135 0 IGZO_DG_BEHAVIORAL_R02 WUM=60 LUM=8
VDS136 D136 0 0.01
VTG136 TG136 0 -0.10000000000000001
VBG136 BG136 0 0
XDEV136 D136 TG136 BG136 0 IGZO_DG_BEHAVIORAL_R02 WUM=60 LUM=8
VDS137 D137 0 0.01
VTG137 TG137 0 -0.050000000000000003
VBG137 BG137 0 0
XDEV137 D137 TG137 BG137 0 IGZO_DG_BEHAVIORAL_R02 WUM=60 LUM=8
VDS138 D138 0 0.01
VTG138 TG138 0 0
VBG138 BG138 0 0
XDEV138 D138 TG138 BG138 0 IGZO_DG_BEHAVIORAL_R02 WUM=60 LUM=8
VDS139 D139 0 0.01
VTG139 TG139 0 0.050000000000000003
VBG139 BG139 0 0
XDEV139 D139 TG139 BG139 0 IGZO_DG_BEHAVIORAL_R02 WUM=60 LUM=8
VDS140 D140 0 0.01
VTG140 TG140 0 0.10000000000000001
VBG140 BG140 0 0
XDEV140 D140 TG140 BG140 0 IGZO_DG_BEHAVIORAL_R02 WUM=60 LUM=8
VDS141 D141 0 0.01
VTG141 TG141 0 0.14999999999999999
VBG141 BG141 0 0
XDEV141 D141 TG141 BG141 0 IGZO_DG_BEHAVIORAL_R02 WUM=60 LUM=8
VDS142 D142 0 0.01
VTG142 TG142 0 0.20000000000000001
VBG142 BG142 0 0
XDEV142 D142 TG142 BG142 0 IGZO_DG_BEHAVIORAL_R02 WUM=60 LUM=8
VDS143 D143 0 0.01
VTG143 TG143 0 0.25
VBG143 BG143 0 0
XDEV143 D143 TG143 BG143 0 IGZO_DG_BEHAVIORAL_R02 WUM=60 LUM=8
VDS144 D144 0 0.01
VTG144 TG144 0 0.29999999999999999
VBG144 BG144 0 0
XDEV144 D144 TG144 BG144 0 IGZO_DG_BEHAVIORAL_R02 WUM=60 LUM=8
VDS145 D145 0 0.01
VTG145 TG145 0 0.34999999999999998
VBG145 BG145 0 0
XDEV145 D145 TG145 BG145 0 IGZO_DG_BEHAVIORAL_R02 WUM=60 LUM=8
VDS146 D146 0 0.01
VTG146 TG146 0 0.40000000000000002
VBG146 BG146 0 0
XDEV146 D146 TG146 BG146 0 IGZO_DG_BEHAVIORAL_R02 WUM=60 LUM=8
VDS147 D147 0 0.01
VTG147 TG147 0 0.45000000000000001
VBG147 BG147 0 0
XDEV147 D147 TG147 BG147 0 IGZO_DG_BEHAVIORAL_R02 WUM=60 LUM=8
VDS148 D148 0 0.01
VTG148 TG148 0 0.5
VBG148 BG148 0 0
XDEV148 D148 TG148 BG148 0 IGZO_DG_BEHAVIORAL_R02 WUM=60 LUM=8
VDS149 D149 0 0.01
VTG149 TG149 0 0.55000000000000004
VBG149 BG149 0 0
XDEV149 D149 TG149 BG149 0 IGZO_DG_BEHAVIORAL_R02 WUM=60 LUM=8
VDS150 D150 0 0.01
VTG150 TG150 0 0.59999999999999998
VBG150 BG150 0 0
XDEV150 D150 TG150 BG150 0 IGZO_DG_BEHAVIORAL_R02 WUM=60 LUM=8
VDS151 D151 0 0.01
VTG151 TG151 0 0.65000000000000002
VBG151 BG151 0 0
XDEV151 D151 TG151 BG151 0 IGZO_DG_BEHAVIORAL_R02 WUM=60 LUM=8
VDS152 D152 0 0.01
VTG152 TG152 0 0.69999999999999996
VBG152 BG152 0 0
XDEV152 D152 TG152 BG152 0 IGZO_DG_BEHAVIORAL_R02 WUM=60 LUM=8
VDS153 D153 0 0.01
VTG153 TG153 0 0.75
VBG153 BG153 0 0
XDEV153 D153 TG153 BG153 0 IGZO_DG_BEHAVIORAL_R02 WUM=60 LUM=8
VDS154 D154 0 0.01
VTG154 TG154 0 0.80000000000000004
VBG154 BG154 0 0
XDEV154 D154 TG154 BG154 0 IGZO_DG_BEHAVIORAL_R02 WUM=60 LUM=8
VDS155 D155 0 0.01
VTG155 TG155 0 0.84999999999999998
VBG155 BG155 0 0
XDEV155 D155 TG155 BG155 0 IGZO_DG_BEHAVIORAL_R02 WUM=60 LUM=8
VDS156 D156 0 0.01
VTG156 TG156 0 0.90000000000000002
VBG156 BG156 0 0
XDEV156 D156 TG156 BG156 0 IGZO_DG_BEHAVIORAL_R02 WUM=60 LUM=8
VDS157 D157 0 0.01
VTG157 TG157 0 0.94999999999999996
VBG157 BG157 0 0
XDEV157 D157 TG157 BG157 0 IGZO_DG_BEHAVIORAL_R02 WUM=60 LUM=8
VDS158 D158 0 0.01
VTG158 TG158 0 1
VBG158 BG158 0 0
XDEV158 D158 TG158 BG158 0 IGZO_DG_BEHAVIORAL_R02 WUM=60 LUM=8
VDS159 D159 0 0
VTG159 TG159 0 0.29999999999999999
VBG159 BG159 0 0
XDEV159 D159 TG159 BG159 0 IGZO_DG_BEHAVIORAL_R02 WUM=60 LUM=10
VDS160 D160 0 0.001
VTG160 TG160 0 0.29999999999999999
VBG160 BG160 0 0
XDEV160 D160 TG160 BG160 0 IGZO_DG_BEHAVIORAL_R02 WUM=60 LUM=10
VDS161 D161 0 0.0050000000000000001
VTG161 TG161 0 0.29999999999999999
VBG161 BG161 0 0
XDEV161 D161 TG161 BG161 0 IGZO_DG_BEHAVIORAL_R02 WUM=60 LUM=10
VDS162 D162 0 0.01
VTG162 TG162 0 0.29999999999999999
VBG162 BG162 0 0
XDEV162 D162 TG162 BG162 0 IGZO_DG_BEHAVIORAL_R02 WUM=60 LUM=10
VDS163 D163 0 0.050000000000000003
VTG163 TG163 0 0.29999999999999999
VBG163 BG163 0 0
XDEV163 D163 TG163 BG163 0 IGZO_DG_BEHAVIORAL_R02 WUM=60 LUM=10
VDS164 D164 0 0.10000000000000001
VTG164 TG164 0 0.29999999999999999
VBG164 BG164 0 0
XDEV164 D164 TG164 BG164 0 IGZO_DG_BEHAVIORAL_R02 WUM=60 LUM=10
VDS165 D165 0 0.20000000000000001
VTG165 TG165 0 0.29999999999999999
VBG165 BG165 0 0
XDEV165 D165 TG165 BG165 0 IGZO_DG_BEHAVIORAL_R02 WUM=60 LUM=10
VDS166 D166 0 0
VTG166 TG166 0 1
VBG166 BG166 0 0
XDEV166 D166 TG166 BG166 0 IGZO_DG_BEHAVIORAL_R02 WUM=60 LUM=10
VDS167 D167 0 0.001
VTG167 TG167 0 1
VBG167 BG167 0 0
XDEV167 D167 TG167 BG167 0 IGZO_DG_BEHAVIORAL_R02 WUM=60 LUM=10
VDS168 D168 0 0.0050000000000000001
VTG168 TG168 0 1
VBG168 BG168 0 0
XDEV168 D168 TG168 BG168 0 IGZO_DG_BEHAVIORAL_R02 WUM=60 LUM=10
VDS169 D169 0 0.01
VTG169 TG169 0 1
VBG169 BG169 0 0
XDEV169 D169 TG169 BG169 0 IGZO_DG_BEHAVIORAL_R02 WUM=60 LUM=10
VDS170 D170 0 0.050000000000000003
VTG170 TG170 0 1
VBG170 BG170 0 0
XDEV170 D170 TG170 BG170 0 IGZO_DG_BEHAVIORAL_R02 WUM=60 LUM=10
VDS171 D171 0 0.10000000000000001
VTG171 TG171 0 1
VBG171 BG171 0 0
XDEV171 D171 TG171 BG171 0 IGZO_DG_BEHAVIORAL_R02 WUM=60 LUM=10
VDS172 D172 0 0.20000000000000001
VTG172 TG172 0 1
VBG172 BG172 0 0
XDEV172 D172 TG172 BG172 0 IGZO_DG_BEHAVIORAL_R02 WUM=60 LUM=10
VDS173 D173 0 0
VTG173 TG173 0 0
VBG173 BG173 0 0.29999999999999999
XDEV173 D173 TG173 BG173 0 IGZO_DG_BEHAVIORAL_R02 WUM=60 LUM=10
VDS174 D174 0 0.01
VTG174 TG174 0 0
VBG174 BG174 0 0.29999999999999999
XDEV174 D174 TG174 BG174 0 IGZO_DG_BEHAVIORAL_R02 WUM=60 LUM=10
VDS175 D175 0 0.050000000000000003
VTG175 TG175 0 0
VBG175 BG175 0 0.29999999999999999
XDEV175 D175 TG175 BG175 0 IGZO_DG_BEHAVIORAL_R02 WUM=60 LUM=10
VDS176 D176 0 0.10000000000000001
VTG176 TG176 0 0
VBG176 BG176 0 0.29999999999999999
XDEV176 D176 TG176 BG176 0 IGZO_DG_BEHAVIORAL_R02 WUM=60 LUM=10
VDS177 D177 0 0.20000000000000001
VTG177 TG177 0 0
VBG177 BG177 0 0.29999999999999999
XDEV177 D177 TG177 BG177 0 IGZO_DG_BEHAVIORAL_R02 WUM=60 LUM=10
VDS178 D178 0 0.01
VTG178 TG178 0 -0.5
VBG178 BG178 0 0
XDEV178 D178 TG178 BG178 0 IGZO_DG_BEHAVIORAL_R02 WUM=60 LUM=10
VDS179 D179 0 0.01
VTG179 TG179 0 -0.45000000000000001
VBG179 BG179 0 0
XDEV179 D179 TG179 BG179 0 IGZO_DG_BEHAVIORAL_R02 WUM=60 LUM=10
VDS180 D180 0 0.01
VTG180 TG180 0 -0.40000000000000002
VBG180 BG180 0 0
XDEV180 D180 TG180 BG180 0 IGZO_DG_BEHAVIORAL_R02 WUM=60 LUM=10
VDS181 D181 0 0.01
VTG181 TG181 0 -0.34999999999999998
VBG181 BG181 0 0
XDEV181 D181 TG181 BG181 0 IGZO_DG_BEHAVIORAL_R02 WUM=60 LUM=10
VDS182 D182 0 0.01
VTG182 TG182 0 -0.29999999999999999
VBG182 BG182 0 0
XDEV182 D182 TG182 BG182 0 IGZO_DG_BEHAVIORAL_R02 WUM=60 LUM=10
VDS183 D183 0 0.01
VTG183 TG183 0 -0.25
VBG183 BG183 0 0
XDEV183 D183 TG183 BG183 0 IGZO_DG_BEHAVIORAL_R02 WUM=60 LUM=10
VDS184 D184 0 0.01
VTG184 TG184 0 -0.20000000000000001
VBG184 BG184 0 0
XDEV184 D184 TG184 BG184 0 IGZO_DG_BEHAVIORAL_R02 WUM=60 LUM=10
VDS185 D185 0 0.01
VTG185 TG185 0 -0.14999999999999999
VBG185 BG185 0 0
XDEV185 D185 TG185 BG185 0 IGZO_DG_BEHAVIORAL_R02 WUM=60 LUM=10
VDS186 D186 0 0.01
VTG186 TG186 0 -0.10000000000000001
VBG186 BG186 0 0
XDEV186 D186 TG186 BG186 0 IGZO_DG_BEHAVIORAL_R02 WUM=60 LUM=10
VDS187 D187 0 0.01
VTG187 TG187 0 -0.050000000000000003
VBG187 BG187 0 0
XDEV187 D187 TG187 BG187 0 IGZO_DG_BEHAVIORAL_R02 WUM=60 LUM=10
VDS188 D188 0 0.01
VTG188 TG188 0 0
VBG188 BG188 0 0
XDEV188 D188 TG188 BG188 0 IGZO_DG_BEHAVIORAL_R02 WUM=60 LUM=10
VDS189 D189 0 0.01
VTG189 TG189 0 0.050000000000000003
VBG189 BG189 0 0
XDEV189 D189 TG189 BG189 0 IGZO_DG_BEHAVIORAL_R02 WUM=60 LUM=10
VDS190 D190 0 0.01
VTG190 TG190 0 0.10000000000000001
VBG190 BG190 0 0
XDEV190 D190 TG190 BG190 0 IGZO_DG_BEHAVIORAL_R02 WUM=60 LUM=10
VDS191 D191 0 0.01
VTG191 TG191 0 0.14999999999999999
VBG191 BG191 0 0
XDEV191 D191 TG191 BG191 0 IGZO_DG_BEHAVIORAL_R02 WUM=60 LUM=10
VDS192 D192 0 0.01
VTG192 TG192 0 0.20000000000000001
VBG192 BG192 0 0
XDEV192 D192 TG192 BG192 0 IGZO_DG_BEHAVIORAL_R02 WUM=60 LUM=10
VDS193 D193 0 0.01
VTG193 TG193 0 0.25
VBG193 BG193 0 0
XDEV193 D193 TG193 BG193 0 IGZO_DG_BEHAVIORAL_R02 WUM=60 LUM=10
VDS194 D194 0 0.01
VTG194 TG194 0 0.29999999999999999
VBG194 BG194 0 0
XDEV194 D194 TG194 BG194 0 IGZO_DG_BEHAVIORAL_R02 WUM=60 LUM=10
VDS195 D195 0 0.01
VTG195 TG195 0 0.34999999999999998
VBG195 BG195 0 0
XDEV195 D195 TG195 BG195 0 IGZO_DG_BEHAVIORAL_R02 WUM=60 LUM=10
VDS196 D196 0 0.01
VTG196 TG196 0 0.40000000000000002
VBG196 BG196 0 0
XDEV196 D196 TG196 BG196 0 IGZO_DG_BEHAVIORAL_R02 WUM=60 LUM=10
VDS197 D197 0 0.01
VTG197 TG197 0 0.45000000000000001
VBG197 BG197 0 0
XDEV197 D197 TG197 BG197 0 IGZO_DG_BEHAVIORAL_R02 WUM=60 LUM=10
VDS198 D198 0 0.01
VTG198 TG198 0 0.5
VBG198 BG198 0 0
XDEV198 D198 TG198 BG198 0 IGZO_DG_BEHAVIORAL_R02 WUM=60 LUM=10
VDS199 D199 0 0.01
VTG199 TG199 0 0.55000000000000004
VBG199 BG199 0 0
XDEV199 D199 TG199 BG199 0 IGZO_DG_BEHAVIORAL_R02 WUM=60 LUM=10
VDS200 D200 0 0.01
VTG200 TG200 0 0.59999999999999998
VBG200 BG200 0 0
XDEV200 D200 TG200 BG200 0 IGZO_DG_BEHAVIORAL_R02 WUM=60 LUM=10
VDS201 D201 0 0.01
VTG201 TG201 0 0.65000000000000002
VBG201 BG201 0 0
XDEV201 D201 TG201 BG201 0 IGZO_DG_BEHAVIORAL_R02 WUM=60 LUM=10
VDS202 D202 0 0.01
VTG202 TG202 0 0.69999999999999996
VBG202 BG202 0 0
XDEV202 D202 TG202 BG202 0 IGZO_DG_BEHAVIORAL_R02 WUM=60 LUM=10
VDS203 D203 0 0.01
VTG203 TG203 0 0.75
VBG203 BG203 0 0
XDEV203 D203 TG203 BG203 0 IGZO_DG_BEHAVIORAL_R02 WUM=60 LUM=10
VDS204 D204 0 0.01
VTG204 TG204 0 0.80000000000000004
VBG204 BG204 0 0
XDEV204 D204 TG204 BG204 0 IGZO_DG_BEHAVIORAL_R02 WUM=60 LUM=10
VDS205 D205 0 0.01
VTG205 TG205 0 0.84999999999999998
VBG205 BG205 0 0
XDEV205 D205 TG205 BG205 0 IGZO_DG_BEHAVIORAL_R02 WUM=60 LUM=10
VDS206 D206 0 0.01
VTG206 TG206 0 0.90000000000000002
VBG206 BG206 0 0
XDEV206 D206 TG206 BG206 0 IGZO_DG_BEHAVIORAL_R02 WUM=60 LUM=10
VDS207 D207 0 0.01
VTG207 TG207 0 0.94999999999999996
VBG207 BG207 0 0
XDEV207 D207 TG207 BG207 0 IGZO_DG_BEHAVIORAL_R02 WUM=60 LUM=10
VDS208 D208 0 0.01
VTG208 TG208 0 1
VBG208 BG208 0 0
XDEV208 D208 TG208 BG208 0 IGZO_DG_BEHAVIORAL_R02 WUM=60 LUM=10
VDS209 D209 0 0.01
VTG209 TG209 0 -0.5
VBG209 BG209 0 0
XDEV209 D209 TG209 BG209 0 IGZO_DG_BEHAVIORAL_R02 WUM=60 LUM=12
VDS210 D210 0 0.01
VTG210 TG210 0 -0.45000000000000001
VBG210 BG210 0 0
XDEV210 D210 TG210 BG210 0 IGZO_DG_BEHAVIORAL_R02 WUM=60 LUM=12
VDS211 D211 0 0.01
VTG211 TG211 0 -0.40000000000000002
VBG211 BG211 0 0
XDEV211 D211 TG211 BG211 0 IGZO_DG_BEHAVIORAL_R02 WUM=60 LUM=12
VDS212 D212 0 0.01
VTG212 TG212 0 -0.34999999999999998
VBG212 BG212 0 0
XDEV212 D212 TG212 BG212 0 IGZO_DG_BEHAVIORAL_R02 WUM=60 LUM=12
VDS213 D213 0 0.01
VTG213 TG213 0 -0.29999999999999999
VBG213 BG213 0 0
XDEV213 D213 TG213 BG213 0 IGZO_DG_BEHAVIORAL_R02 WUM=60 LUM=12
VDS214 D214 0 0.01
VTG214 TG214 0 -0.25
VBG214 BG214 0 0
XDEV214 D214 TG214 BG214 0 IGZO_DG_BEHAVIORAL_R02 WUM=60 LUM=12
VDS215 D215 0 0.01
VTG215 TG215 0 -0.20000000000000001
VBG215 BG215 0 0
XDEV215 D215 TG215 BG215 0 IGZO_DG_BEHAVIORAL_R02 WUM=60 LUM=12
VDS216 D216 0 0.01
VTG216 TG216 0 -0.14999999999999999
VBG216 BG216 0 0
XDEV216 D216 TG216 BG216 0 IGZO_DG_BEHAVIORAL_R02 WUM=60 LUM=12
VDS217 D217 0 0.01
VTG217 TG217 0 -0.10000000000000001
VBG217 BG217 0 0
XDEV217 D217 TG217 BG217 0 IGZO_DG_BEHAVIORAL_R02 WUM=60 LUM=12
VDS218 D218 0 0.01
VTG218 TG218 0 -0.050000000000000003
VBG218 BG218 0 0
XDEV218 D218 TG218 BG218 0 IGZO_DG_BEHAVIORAL_R02 WUM=60 LUM=12
VDS219 D219 0 0.01
VTG219 TG219 0 0
VBG219 BG219 0 0
XDEV219 D219 TG219 BG219 0 IGZO_DG_BEHAVIORAL_R02 WUM=60 LUM=12
VDS220 D220 0 0.01
VTG220 TG220 0 0.050000000000000003
VBG220 BG220 0 0
XDEV220 D220 TG220 BG220 0 IGZO_DG_BEHAVIORAL_R02 WUM=60 LUM=12
VDS221 D221 0 0.01
VTG221 TG221 0 0.10000000000000001
VBG221 BG221 0 0
XDEV221 D221 TG221 BG221 0 IGZO_DG_BEHAVIORAL_R02 WUM=60 LUM=12
VDS222 D222 0 0.01
VTG222 TG222 0 0.14999999999999999
VBG222 BG222 0 0
XDEV222 D222 TG222 BG222 0 IGZO_DG_BEHAVIORAL_R02 WUM=60 LUM=12
VDS223 D223 0 0.01
VTG223 TG223 0 0.20000000000000001
VBG223 BG223 0 0
XDEV223 D223 TG223 BG223 0 IGZO_DG_BEHAVIORAL_R02 WUM=60 LUM=12
VDS224 D224 0 0.01
VTG224 TG224 0 0.25
VBG224 BG224 0 0
XDEV224 D224 TG224 BG224 0 IGZO_DG_BEHAVIORAL_R02 WUM=60 LUM=12
VDS225 D225 0 0.01
VTG225 TG225 0 0.29999999999999999
VBG225 BG225 0 0
XDEV225 D225 TG225 BG225 0 IGZO_DG_BEHAVIORAL_R02 WUM=60 LUM=12
VDS226 D226 0 0.01
VTG226 TG226 0 0.34999999999999998
VBG226 BG226 0 0
XDEV226 D226 TG226 BG226 0 IGZO_DG_BEHAVIORAL_R02 WUM=60 LUM=12
VDS227 D227 0 0.01
VTG227 TG227 0 0.40000000000000002
VBG227 BG227 0 0
XDEV227 D227 TG227 BG227 0 IGZO_DG_BEHAVIORAL_R02 WUM=60 LUM=12
VDS228 D228 0 0.01
VTG228 TG228 0 0.45000000000000001
VBG228 BG228 0 0
XDEV228 D228 TG228 BG228 0 IGZO_DG_BEHAVIORAL_R02 WUM=60 LUM=12
VDS229 D229 0 0.01
VTG229 TG229 0 0.5
VBG229 BG229 0 0
XDEV229 D229 TG229 BG229 0 IGZO_DG_BEHAVIORAL_R02 WUM=60 LUM=12
VDS230 D230 0 0.01
VTG230 TG230 0 0.55000000000000004
VBG230 BG230 0 0
XDEV230 D230 TG230 BG230 0 IGZO_DG_BEHAVIORAL_R02 WUM=60 LUM=12
VDS231 D231 0 0.01
VTG231 TG231 0 0.59999999999999998
VBG231 BG231 0 0
XDEV231 D231 TG231 BG231 0 IGZO_DG_BEHAVIORAL_R02 WUM=60 LUM=12
VDS232 D232 0 0.01
VTG232 TG232 0 0.65000000000000002
VBG232 BG232 0 0
XDEV232 D232 TG232 BG232 0 IGZO_DG_BEHAVIORAL_R02 WUM=60 LUM=12
VDS233 D233 0 0.01
VTG233 TG233 0 0.69999999999999996
VBG233 BG233 0 0
XDEV233 D233 TG233 BG233 0 IGZO_DG_BEHAVIORAL_R02 WUM=60 LUM=12
VDS234 D234 0 0.01
VTG234 TG234 0 0.75
VBG234 BG234 0 0
XDEV234 D234 TG234 BG234 0 IGZO_DG_BEHAVIORAL_R02 WUM=60 LUM=12
VDS235 D235 0 0.01
VTG235 TG235 0 0.80000000000000004
VBG235 BG235 0 0
XDEV235 D235 TG235 BG235 0 IGZO_DG_BEHAVIORAL_R02 WUM=60 LUM=12
VDS236 D236 0 0.01
VTG236 TG236 0 0.84999999999999998
VBG236 BG236 0 0
XDEV236 D236 TG236 BG236 0 IGZO_DG_BEHAVIORAL_R02 WUM=60 LUM=12
VDS237 D237 0 0.01
VTG237 TG237 0 0.90000000000000002
VBG237 BG237 0 0
XDEV237 D237 TG237 BG237 0 IGZO_DG_BEHAVIORAL_R02 WUM=60 LUM=12
VDS238 D238 0 0.01
VTG238 TG238 0 0.94999999999999996
VBG238 BG238 0 0
XDEV238 D238 TG238 BG238 0 IGZO_DG_BEHAVIORAL_R02 WUM=60 LUM=12
VDS239 D239 0 0.01
VTG239 TG239 0 1
VBG239 BG239 0 0
XDEV239 D239 TG239 BG239 0 IGZO_DG_BEHAVIORAL_R02 WUM=60 LUM=12
VDS240 D240 0 0
VTG240 TG240 0 0.5
VBG240 BG240 0 0
XDEV240 D240 TG240 BG240 0 IGZO_DG_BEHAVIORAL_R02 WUM=60 LUM=10
VDS241 D241 0 0.001
VTG241 TG241 0 0.5
VBG241 BG241 0 0
XDEV241 D241 TG241 BG241 0 IGZO_DG_BEHAVIORAL_R02 WUM=60 LUM=10
VDS242 D242 0 0.0050000000000000001
VTG242 TG242 0 0.5
VBG242 BG242 0 0
XDEV242 D242 TG242 BG242 0 IGZO_DG_BEHAVIORAL_R02 WUM=60 LUM=10
VDS243 D243 0 0.01
VTG243 TG243 0 0.5
VBG243 BG243 0 0
XDEV243 D243 TG243 BG243 0 IGZO_DG_BEHAVIORAL_R02 WUM=60 LUM=10
VDS244 D244 0 0.050000000000000003
VTG244 TG244 0 0.5
VBG244 BG244 0 0
XDEV244 D244 TG244 BG244 0 IGZO_DG_BEHAVIORAL_R02 WUM=60 LUM=10
VDS245 D245 0 0.10000000000000001
VTG245 TG245 0 0.5
VBG245 BG245 0 0
XDEV245 D245 TG245 BG245 0 IGZO_DG_BEHAVIORAL_R02 WUM=60 LUM=10
VDS246 D246 0 0.20000000000000001
VTG246 TG246 0 0.5
VBG246 BG246 0 0
XDEV246 D246 TG246 BG246 0 IGZO_DG_BEHAVIORAL_R02 WUM=60 LUM=10
.DC VSWEEP 0 0 1
.save I(VDS000) I(VDS001) I(VDS002) I(VDS003) I(VDS004) I(VDS005) I(VDS006) I(VDS007)
+ I(VDS008) I(VDS009) I(VDS010) I(VDS011) I(VDS012) I(VDS013) I(VDS014) I(VDS015)
+ I(VDS016) I(VDS017) I(VDS018) I(VDS019) I(VDS020) I(VDS021) I(VDS022) I(VDS023)
+ I(VDS024) I(VDS025) I(VDS026) I(VDS027) I(VDS028) I(VDS029) I(VDS030) I(VDS031)
+ I(VDS032) I(VDS033) I(VDS034) I(VDS035) I(VDS036) I(VDS037) I(VDS038) I(VDS039)
+ I(VDS040) I(VDS041) I(VDS042) I(VDS043) I(VDS044) I(VDS045) I(VDS046) I(VDS047)
+ I(VDS048) I(VDS049) I(VDS050) I(VDS051) I(VDS052) I(VDS053) I(VDS054) I(VDS055)
+ I(VDS056) I(VDS057) I(VDS058) I(VDS059) I(VDS060) I(VDS061) I(VDS062) I(VDS063)
+ I(VDS064) I(VDS065) I(VDS066) I(VDS067) I(VDS068) I(VDS069) I(VDS070) I(VDS071)
+ I(VDS072) I(VDS073) I(VDS074) I(VDS075) I(VDS076) I(VDS077) I(VDS078) I(VDS079)
+ I(VDS080) I(VDS081) I(VDS082) I(VDS083) I(VDS084) I(VDS085) I(VDS086) I(VDS087)
+ I(VDS088) I(VDS089) I(VDS090) I(VDS091) I(VDS092) I(VDS093) I(VDS094) I(VDS095)
+ I(VDS096) I(VDS097) I(VDS098) I(VDS099) I(VDS100) I(VDS101) I(VDS102) I(VDS103)
+ I(VDS104) I(VDS105) I(VDS106) I(VDS107) I(VDS108) I(VDS109) I(VDS110) I(VDS111)
+ I(VDS112) I(VDS113) I(VDS114) I(VDS115) I(VDS116) I(VDS117) I(VDS118) I(VDS119)
+ I(VDS120) I(VDS121) I(VDS122) I(VDS123) I(VDS124) I(VDS125) I(VDS126) I(VDS127)
+ I(VDS128) I(VDS129) I(VDS130) I(VDS131) I(VDS132) I(VDS133) I(VDS134) I(VDS135)
+ I(VDS136) I(VDS137) I(VDS138) I(VDS139) I(VDS140) I(VDS141) I(VDS142) I(VDS143)
+ I(VDS144) I(VDS145) I(VDS146) I(VDS147) I(VDS148) I(VDS149) I(VDS150) I(VDS151)
+ I(VDS152) I(VDS153) I(VDS154) I(VDS155) I(VDS156) I(VDS157) I(VDS158) I(VDS159)
+ I(VDS160) I(VDS161) I(VDS162) I(VDS163) I(VDS164) I(VDS165) I(VDS166) I(VDS167)
+ I(VDS168) I(VDS169) I(VDS170) I(VDS171) I(VDS172) I(VDS173) I(VDS174) I(VDS175)
+ I(VDS176) I(VDS177) I(VDS178) I(VDS179) I(VDS180) I(VDS181) I(VDS182) I(VDS183)
+ I(VDS184) I(VDS185) I(VDS186) I(VDS187) I(VDS188) I(VDS189) I(VDS190) I(VDS191)
+ I(VDS192) I(VDS193) I(VDS194) I(VDS195) I(VDS196) I(VDS197) I(VDS198) I(VDS199)
+ I(VDS200) I(VDS201) I(VDS202) I(VDS203) I(VDS204) I(VDS205) I(VDS206) I(VDS207)
+ I(VDS208) I(VDS209) I(VDS210) I(VDS211) I(VDS212) I(VDS213) I(VDS214) I(VDS215)
+ I(VDS216) I(VDS217) I(VDS218) I(VDS219) I(VDS220) I(VDS221) I(VDS222) I(VDS223)
+ I(VDS224) I(VDS225) I(VDS226) I(VDS227) I(VDS228) I(VDS229) I(VDS230) I(VDS231)
+ I(VDS232) I(VDS233) I(VDS234) I(VDS235) I(VDS236) I(VDS237) I(VDS238) I(VDS239)
+ I(VDS240) I(VDS241) I(VDS242) I(VDS243) I(VDS244) I(VDS245) I(VDS246)
.control
set filetype=ascii
run
write results/compact/m01_open_source_cross_check_r02/ngspice_values.raw
quit
.endc
.end
